# Ansys Electronics Desktop project, version 2021.1
materials:
  Air: thermal_conductivity=0.0261 mass_density=1.1614 specific_heat=1005 thermal_expansion_coefficient=0.00333 thermal_material_type=Fluid diffusivity=2.88e-05 molecular_mass=0.028966 viscosity=1.84e-05
  CoreMat: thermal_conductivity=4
  CondMat1_1: thermal_conductivity=400
  CondMat1_2: thermal_conductivity=400
  CondMat1_3: thermal_conductivity=400
  CondMat1_4: thermal_conductivity=400
  CondMat1_5: thermal_conductivity=400
  CondMat1_6: thermal_conductivity=400
  CondMat2_1: thermal_conductivity=400
  CondMat2_2: thermal_conductivity=400
  CondMat2_3: thermal_conductivity=400
  CondMat2_4: thermal_conductivity=400
  CondMat2_5: thermal_conductivity=400
  CondMat2_6: thermal_conductivity=400
  CondMat3_1: thermal_conductivity=400
  CondMat3_2: thermal_conductivity=400
  CondMat3_3: thermal_conductivity=400
  CondMat3_4: thermal_conductivity=400
  CondMat3_5: thermal_conductivity=400
  CondMat3_6: thermal_conductivity=400
  CondMat4_1: thermal_conductivity=400
  CondMat4_2: thermal_conductivity=400
  CondMat4_3: thermal_conductivity=400
  CondMat4_4: thermal_conductivity=400
  CondMat4_5: thermal_conductivity=400
  CondMat4_6: thermal_conductivity=400
  CondMat5_1: thermal_conductivity=400
  CondMat5_2: thermal_conductivity=400
  CondMat6_1: thermal_conductivity=400
  CondMat6_2: thermal_conductivity=400
  CondMat7_1: thermal_conductivity=400
  CondMat7_2: thermal_conductivity=400
  CondMat8_1: thermal_conductivity=400
  CondMat8_2: thermal_conductivity=400
  CondMat9_1: thermal_conductivity=400
  CondMat9_2: thermal_conductivity=400
  CondMat10_1: thermal_conductivity=400
  CondMat10_2: thermal_conductivity=400
  CondMat11_1: thermal_conductivity=400
  CondMat11_2: thermal_conductivity=400
  CondMat12_1: thermal_conductivity=400
  CondMat12_2: thermal_conductivity=400
  CondMat13_1: thermal_conductivity=400
  CondMat13_2: thermal_conductivity=400
  CondMat14_1: thermal_conductivity=400
  CondMat14_2: thermal_conductivity=400
  CondMat15_1: thermal_conductivity=400
  CondMat15_2: thermal_conductivity=400
  CondMat16_1: thermal_conductivity=400
  CondMat16_2: thermal_conductivity=400
  Al-Extruded: thermal_conductivity=205 mass_density=2800 specific_heat=900 thermal_material_type=Solid
surface materials:
  CoreMat_surface: surface_emissivity=0.4
  CondMat1_1_surface: surface_emissivity=0.95
  CondMat1_2_surface: surface_emissivity=0.95
  CondMat1_3_surface: surface_emissivity=0.95
  CondMat1_4_surface: surface_emissivity=0.95
  CondMat1_5_surface: surface_emissivity=0.95
  CondMat1_6_surface: surface_emissivity=0.95
  CondMat2_1_surface: surface_emissivity=0.95
  CondMat2_2_surface: surface_emissivity=0.95
  CondMat2_3_surface: surface_emissivity=0.95
  CondMat2_4_surface: surface_emissivity=0.95
  CondMat2_5_surface: surface_emissivity=0.95
  CondMat2_6_surface: surface_emissivity=0.95
  CondMat3_1_surface: surface_emissivity=0.95
  CondMat3_2_surface: surface_emissivity=0.95
  CondMat3_3_surface: surface_emissivity=0.95
  CondMat3_4_surface: surface_emissivity=0.95
  CondMat3_5_surface: surface_emissivity=0.95
  CondMat3_6_surface: surface_emissivity=0.95
  CondMat4_1_surface: surface_emissivity=0.95
  CondMat4_2_surface: surface_emissivity=0.95
  CondMat4_3_surface: surface_emissivity=0.95
  CondMat4_4_surface: surface_emissivity=0.95
  CondMat4_5_surface: surface_emissivity=0.95
  CondMat4_6_surface: surface_emissivity=0.95
  CondMat5_1_surface: surface_emissivity=0.95
  CondMat5_2_surface: surface_emissivity=0.95
  CondMat6_1_surface: surface_emissivity=0.95
  CondMat6_2_surface: surface_emissivity=0.95
  CondMat7_1_surface: surface_emissivity=0.95
  CondMat7_2_surface: surface_emissivity=0.95
  CondMat8_1_surface: surface_emissivity=0.95
  CondMat8_2_surface: surface_emissivity=0.95
  CondMat9_1_surface: surface_emissivity=0.95
  CondMat9_2_surface: surface_emissivity=0.95
  CondMat10_1_surface: surface_emissivity=0.95
  CondMat10_2_surface: surface_emissivity=0.95
  CondMat11_1_surface: surface_emissivity=0.95
  CondMat11_2_surface: surface_emissivity=0.95
  CondMat12_1_surface: surface_emissivity=0.95
  CondMat12_2_surface: surface_emissivity=0.95
  CondMat13_1_surface: surface_emissivity=0.95
  CondMat13_2_surface: surface_emissivity=0.95
  CondMat14_1_surface: surface_emissivity=0.95
  CondMat14_2_surface: surface_emissivity=0.95
  CondMat15_1_surface: surface_emissivity=0.95
  CondMat15_2_surface: surface_emissivity=0.95
  CondMat16_1_surface: surface_emissivity=0.95
  CondMat16_2_surface: surface_emissivity=0.95
  Steel-oxidised-surface: surface_emissivity=0.8

design SourceForMesh (Icepak, SteadyState TemperatureAndFlow, model units mm)
notes: Icepak project created by PExprt(TM) Release 2021 R1
© 2021 UPM-SAS IP, Inc.
options: Default_Fluid_Material=air Default_Solid_Material=Al-Extruded Default_Surface_Material=Steel-Oxidised-surface AmbientTemperature=25cel AmbientPressure=0n_per_meter_sq AmbientRadiationTemperature=25cel Gravity_Vector_CS_ID=Global Gravity_Vector_Axis=Z Positive=false Notes="Icepak project created by PExprt(TM) Release 2021 R1 / © 2021 UPM-SAS IP, Inc."
variables:
  Pcore = 0.004341W
  P1 = 0.009658W
  P2 = 0.008802W
geometry:
  Region [Air] = region(absolute_position: +X=141.3mm, -X=-141.3mm, +Y=96mm, -Y=-96mm, +Z=30.6mm, -Z=-30.6mm)
  BoundingBox = box(corner=(-141.3mm, -96mm, -30.6mm), size=(282.6mm, 192mm, 61.2mm))
  BoundingBox_Section1 [Air, surface Steel-oxidised-surface, non-model] = BoundingBox.section(plane=YZ)
  BoundingBox_Section2 [Air, surface Steel-oxidised-surface, non-model] = BoundingBox.section(plane=ZX)
  BoundingBox_Section3 [Air, surface Steel-oxidised-surface, non-model] = BoundingBox.section(plane=XY)
  BoundingBox.delete()
  Core [CoreMat, surface CoreMat_surface] = box(corner=(-25.4mm, -32mm, -10.2mm), size=(50.8mm, 64mm, 20.4mm))
  ToolCore_1 = box(corner=(-26.4mm, -26.8mm, -5.1mm), size=(52.8mm, 21.7mm, 10.2mm))
  Core.subtract(ToolCore_1)
  ToolCore_2 = box(corner=(-26.4mm, 5.1mm, -5.1mm), size=(52.8mm, 21.7mm, 10.2mm))
  Core.subtract(ToolCore_2)
  ToolCore_3 = box(corner=(-26.4mm, -6.1mm, -1.40697mm), size=(52.8mm, 12.2mm, 2.81393mm))
  Core.subtract(ToolCore_3)
  C1_3 [CondMat1_1, surface CondMat1_1_surface] = rectangle(corner=(0mm, -7.28333mm, -0.05mm), y_size=7.03333mm, z_size=0.1mm)
  C1_3.sweep_around_axis(axis=Z, angle=90deg, segments=15)
  C1_3.move(25.4mm, -5.1mm, 5.05mm)
  ToolC1_3_1 = box(corner=(32.68333mm, -5.1mm, 5mm), size=(-7.03333mm, 10.2mm, 0.1mm))
  ToolC1_3_2 = rectangle(corner=(7.28333mm, 0mm, -0.05mm), z_size=0.1mm, x_size=-7.03333mm)
  ToolC1_3_2.sweep_around_axis(axis=Z, angle=90deg, segments=15)
  ToolC1_3_2.move(25.4mm, 5.1mm, 5.05mm)
  ToolC1_3_3 = box(corner=(25.4mm, 12.38333mm, 5mm), size=(-50.8mm, -7.03333mm, 0.1mm))
  ToolC1_3_4 = rectangle(corner=(0mm, 7.28333mm, -0.05mm), y_size=-7.03333mm, z_size=0.1mm)
  ToolC1_3_4.sweep_around_axis(axis=Z, angle=90deg, segments=15)
  ToolC1_3_4.move(-25.4mm, 5.1mm, 5.05mm)
  ToolC1_3_5 = box(corner=(-32.68333mm, 5.1mm, 5mm), size=(7.03333mm, -10.2mm, 0.1mm))
  ToolC1_3_6 = rectangle(corner=(-7.28333mm, 0mm, -0.05mm), z_size=0.1mm, x_size=7.03333mm)
  ToolC1_3_6.sweep_around_axis(axis=Z, angle=90deg, segments=15)
  ToolC1_3_6.move(-25.4mm, -5.1mm, 5.05mm)
  ToolC1_3_7 = box(corner=(-25.4mm, -12.38333mm, 5mm), size=(50.8mm, 7.03333mm, 0.1mm))
  C1_3.unite(ToolC1_3_1..ToolC1_3_7)
  C1_2 [CondMat1_1, surface CondMat1_1_surface] = rectangle(corner=(0mm, -14.36666mm, -0.05mm), y_size=7.03333mm, z_size=0.1mm)
  C1_2.sweep_around_axis(axis=Z, angle=90deg, segments=15)
  C1_2.move(25.4mm, -5.1mm, 5.05mm)
  ToolC1_2_1 = box(corner=(39.76666mm, -5.1mm, 5mm), size=(-7.03333mm, 10.2mm, 0.1mm))
  ToolC1_2_2 = rectangle(corner=(14.36666mm, 0mm, -0.05mm), z_size=0.1mm, x_size=-7.03333mm)
  ToolC1_2_2.sweep_around_axis(axis=Z, angle=90deg, segments=15)
  ToolC1_2_2.move(25.4mm, 5.1mm, 5.05mm)
  ToolC1_2_3 = box(corner=(25.4mm, 19.46666mm, 5mm), size=(-50.8mm, -7.03333mm, 0.1mm))
  ToolC1_2_4 = rectangle(corner=(0mm, 14.36666mm, -0.05mm), y_size=-7.03333mm, z_size=0.1mm)
  ToolC1_2_4.sweep_around_axis(axis=Z, angle=90deg, segments=15)
  ToolC1_2_4.move(-25.4mm, 5.1mm, 5.05mm)
  ToolC1_2_5 = box(corner=(-39.76666mm, 5.1mm, 5mm), size=(7.03333mm, -10.2mm, 0.1mm))
  ToolC1_2_6 = rectangle(corner=(-14.36666mm, 0mm, -0.05mm), z_size=0.1mm, x_size=7.03333mm)
  ToolC1_2_6.sweep_around_axis(axis=Z, angle=90deg, segments=15)
  ToolC1_2_6.move(-25.4mm, -5.1mm, 5.05mm)
  ToolC1_2_7 = box(corner=(-25.4mm, -19.46666mm, 5mm), size=(50.8mm, 7.03333mm, 0.1mm))
  C1_2.unite(ToolC1_2_1..ToolC1_2_7)
  C1_1 [CondMat1_1, surface CondMat1_1_surface] = rectangle(corner=(0mm, -21.45mm, -0.05mm), y_size=7.03333mm, z_size=0.1mm)
  C1_1.sweep_around_axis(axis=Z, angle=90deg, segments=15)
  C1_1.move(25.4mm, -5.1mm, 5.05mm)
  ToolC1_1_1 = box(corner=(46.85mm, -5.1mm, 5mm), size=(-7.03333mm, 10.2mm, 0.1mm))
  ToolC1_1_2 = rectangle(corner=(21.45mm, 0mm, -0.05mm), z_size=0.1mm, x_size=-7.03333mm)
  ToolC1_1_2.sweep_around_axis(axis=Z, angle=90deg, segments=15)
  ToolC1_1_2.move(25.4mm, 5.1mm, 5.05mm)
  ToolC1_1_3 = box(corner=(25.4mm, 26.55mm, 5mm), size=(-50.8mm, -7.03333mm, 0.1mm))
  ToolC1_1_4 = rectangle(corner=(0mm, 21.45mm, -0.05mm), y_size=-7.03333mm, z_size=0.1mm)
  ToolC1_1_4.sweep_around_axis(axis=Z, angle=90deg, segments=15)
  ToolC1_1_4.move(-25.4mm, 5.1mm, 5.05mm)
  ToolC1_1_5 = box(corner=(-46.85mm, 5.1mm, 5mm), size=(7.03333mm, -10.2mm, 0.1mm))
  ToolC1_1_6 = rectangle(corner=(-21.45mm, 0mm, -0.05mm), z_size=0.1mm, x_size=7.03333mm)
  ToolC1_1_6.sweep_around_axis(axis=Z, angle=90deg, segments=15)
  ToolC1_1_6.move(-25.4mm, -5.1mm, 5.05mm)
  ToolC1_1_7 = box(corner=(-25.4mm, -26.55mm, 5mm), size=(50.8mm, 7.03333mm, 0.1mm))
  C1_1.unite(ToolC1_1_1..ToolC1_1_7)
  C1_6 [CondMat1_2, surface CondMat1_2_surface] = rectangle(corner=(0mm, -7.28333mm, -0.05mm), y_size=7.03333mm, z_size=0.1mm)
  C1_6.sweep_around_axis(axis=Z, angle=90deg, segments=15)
  C1_6.move(25.4mm, -5.1mm, 4.85mm)
  ToolC1_6_1 = box(corner=(32.68333mm, -5.1mm, 4.8mm), size=(-7.03333mm, 10.2mm, 0.1mm))
  ToolC1_6_2 = rectangle(corner=(7.28333mm, 0mm, -0.05mm), z_size=0.1mm, x_size=-7.03333mm)
  ToolC1_6_2.sweep_around_axis(axis=Z, angle=90deg, segments=15)
  ToolC1_6_2.move(25.4mm, 5.1mm, 4.85mm)
  ToolC1_6_3 = box(corner=(25.4mm, 12.38333mm, 4.8mm), size=(-50.8mm, -7.03333mm, 0.1mm))
  ToolC1_6_4 = rectangle(corner=(0mm, 7.28333mm, -0.05mm), y_size=-7.03333mm, z_size=0.1mm)
  ToolC1_6_4.sweep_around_axis(axis=Z, angle=90deg, segments=15)
  ToolC1_6_4.move(-25.4mm, 5.1mm, 4.85mm)
  ToolC1_6_5 = box(corner=(-32.68333mm, 5.1mm, 4.8mm), size=(7.03333mm, -10.2mm, 0.1mm))
  ToolC1_6_6 = rectangle(corner=(-7.28333mm, 0mm, -0.05mm), z_size=0.1mm, x_size=7.03333mm)
  ToolC1_6_6.sweep_around_axis(axis=Z, angle=90deg, segments=15)
  ToolC1_6_6.move(-25.4mm, -5.1mm, 4.85mm)
  ToolC1_6_7 = box(corner=(-25.4mm, -12.38333mm, 4.8mm), size=(50.8mm, 7.03333mm, 0.1mm))
  C1_6.unite(ToolC1_6_1..ToolC1_6_7)
  C1_5 [CondMat1_2, surface CondMat1_2_surface] = rectangle(corner=(0mm, -14.36666mm, -0.05mm), y_size=7.03333mm, z_size=0.1mm)
  C1_5.sweep_around_axis(axis=Z, angle=90deg, segments=15)
  C1_5.move(25.4mm, -5.1mm, 4.85mm)
  ToolC1_5_1 = box(corner=(39.76666mm, -5.1mm, 4.8mm), size=(-7.03333mm, 10.2mm, 0.1mm))
  ToolC1_5_2 = rectangle(corner=(14.36666mm, 0mm, -0.05mm), z_size=0.1mm, x_size=-7.03333mm)
  ToolC1_5_2.sweep_around_axis(axis=Z, angle=90deg, segments=15)
  ToolC1_5_2.move(25.4mm, 5.1mm, 4.85mm)
  ToolC1_5_3 = box(corner=(25.4mm, 19.46666mm, 4.8mm), size=(-50.8mm, -7.03333mm, 0.1mm))
  ToolC1_5_4 = rectangle(corner=(0mm, 14.36666mm, -0.05mm), y_size=-7.03333mm, z_size=0.1mm)
  ToolC1_5_4.sweep_around_axis(axis=Z, angle=90deg, segments=15)
  ToolC1_5_4.move(-25.4mm, 5.1mm, 4.85mm)
  ToolC1_5_5 = box(corner=(-39.76666mm, 5.1mm, 4.8mm), size=(7.03333mm, -10.2mm, 0.1mm))
  ToolC1_5_6 = rectangle(corner=(-14.36666mm, 0mm, -0.05mm), z_size=0.1mm, x_size=7.03333mm)
  ToolC1_5_6.sweep_around_axis(axis=Z, angle=90deg, segments=15)
  ToolC1_5_6.move(-25.4mm, -5.1mm, 4.85mm)
  ToolC1_5_7 = box(corner=(-25.4mm, -19.46666mm, 4.8mm), size=(50.8mm, 7.03333mm, 0.1mm))
  C1_5.unite(ToolC1_5_1..ToolC1_5_7)
  C1_4 [CondMat1_2, surface CondMat1_2_surface] = rectangle(corner=(0mm, -21.45mm, -0.05mm), y_size=7.03333mm, z_size=0.1mm)
  C1_4.sweep_around_axis(axis=Z, angle=90deg, segments=15)
  C1_4.move(25.4mm, -5.1mm, 4.85mm)
  ToolC1_4_1 = box(corner=(46.85mm, -5.1mm, 4.8mm), size=(-7.03333mm, 10.2mm, 0.1mm))
  ToolC1_4_2 = rectangle(corner=(21.45mm, 0mm, -0.05mm), z_size=0.1mm, x_size=-7.03333mm)
  ToolC1_4_2.sweep_around_axis(axis=Z, angle=90deg, segments=15)
  ToolC1_4_2.move(25.4mm, 5.1mm, 4.85mm)
  ToolC1_4_3 = box(corner=(25.4mm, 26.55mm, 4.8mm), size=(-50.8mm, -7.03333mm, 0.1mm))
  ToolC1_4_4 = rectangle(corner=(0mm, 21.45mm, -0.05mm), y_size=-7.03333mm, z_size=0.1mm)
  ToolC1_4_4.sweep_around_axis(axis=Z, angle=90deg, segments=15)
  ToolC1_4_4.move(-25.4mm, 5.1mm, 4.85mm)
  ToolC1_4_5 = box(corner=(-46.85mm, 5.1mm, 4.8mm), size=(7.03333mm, -10.2mm, 0.1mm))
  ToolC1_4_6 = rectangle(corner=(-21.45mm, 0mm, -0.05mm), z_size=0.1mm, x_size=7.03333mm)
  ToolC1_4_6.sweep_around_axis(axis=Z, angle=90deg, segments=15)
  ToolC1_4_6.move(-25.4mm, -5.1mm, 4.85mm)
  ToolC1_4_7 = box(corner=(-25.4mm, -26.55mm, 4.8mm), size=(50.8mm, 7.03333mm, 0.1mm))
  C1_4.unite(ToolC1_4_1..ToolC1_4_7)
  C1_9 [CondMat1_3, surface CondMat1_3_surface] = rectangle(corner=(0mm, -7.28333mm, -0.05mm), y_size=7.03333mm, z_size=0.1mm)
  C1_9.sweep_around_axis(axis=Z, angle=90deg, segments=15)
  C1_9.move(25.4mm, -5.1mm, 4.65mm)
  ToolC1_9_1 = box(corner=(32.68333mm, -5.1mm, 4.6mm), size=(-7.03333mm, 10.2mm, 0.1mm))
  ToolC1_9_2 = rectangle(corner=(7.28333mm, 0mm, -0.05mm), z_size=0.1mm, x_size=-7.03333mm)
  ToolC1_9_2.sweep_around_axis(axis=Z, angle=90deg, segments=15)
  ToolC1_9_2.move(25.4mm, 5.1mm, 4.65mm)
  ToolC1_9_3 = box(corner=(25.4mm, 12.38333mm, 4.6mm), size=(-50.8mm, -7.03333mm, 0.1mm))
  ToolC1_9_4 = rectangle(corner=(0mm, 7.28333mm, -0.05mm), y_size=-7.03333mm, z_size=0.1mm)
  ToolC1_9_4.sweep_around_axis(axis=Z, angle=90deg, segments=15)
  ToolC1_9_4.move(-25.4mm, 5.1mm, 4.65mm)
  ToolC1_9_5 = box(corner=(-32.68333mm, 5.1mm, 4.6mm), size=(7.03333mm, -10.2mm, 0.1mm))
  ToolC1_9_6 = rectangle(corner=(-7.28333mm, 0mm, -0.05mm), z_size=0.1mm, x_size=7.03333mm)
  ToolC1_9_6.sweep_around_axis(axis=Z, angle=90deg, segments=15)
  ToolC1_9_6.move(-25.4mm, -5.1mm, 4.65mm)
  ToolC1_9_7 = box(corner=(-25.4mm, -12.38333mm, 4.6mm), size=(50.8mm, 7.03333mm, 0.1mm))
  C1_9.unite(ToolC1_9_1..ToolC1_9_7)
  C1_8 [CondMat1_3, surface CondMat1_3_surface] = rectangle(corner=(0mm, -14.36666mm, -0.05mm), y_size=7.03333mm, z_size=0.1mm)
  C1_8.sweep_around_axis(axis=Z, angle=90deg, segments=15)
  C1_8.move(25.4mm, -5.1mm, 4.65mm)
  ToolC1_8_1 = box(corner=(39.76666mm, -5.1mm, 4.6mm), size=(-7.03333mm, 10.2mm, 0.1mm))
  ToolC1_8_2 = rectangle(corner=(14.36666mm, 0mm, -0.05mm), z_size=0.1mm, x_size=-7.03333mm)
  ToolC1_8_2.sweep_around_axis(axis=Z, angle=90deg, segments=15)
  ToolC1_8_2.move(25.4mm, 5.1mm, 4.65mm)
  ToolC1_8_3 = box(corner=(25.4mm, 19.46666mm, 4.6mm), size=(-50.8mm, -7.03333mm, 0.1mm))
  ToolC1_8_4 = rectangle(corner=(0mm, 14.36666mm, -0.05mm), y_size=-7.03333mm, z_size=0.1mm)
  ToolC1_8_4.sweep_around_axis(axis=Z, angle=90deg, segments=15)
  ToolC1_8_4.move(-25.4mm, 5.1mm, 4.65mm)
  ToolC1_8_5 = box(corner=(-39.76666mm, 5.1mm, 4.6mm), size=(7.03333mm, -10.2mm, 0.1mm))
  ToolC1_8_6 = rectangle(corner=(-14.36666mm, 0mm, -0.05mm), z_size=0.1mm, x_size=7.03333mm)
  ToolC1_8_6.sweep_around_axis(axis=Z, angle=90deg, segments=15)
  ToolC1_8_6.move(-25.4mm, -5.1mm, 4.65mm)
  ToolC1_8_7 = box(corner=(-25.4mm, -19.46666mm, 4.6mm), size=(50.8mm, 7.03333mm, 0.1mm))
  C1_8.unite(ToolC1_8_1..ToolC1_8_7)
  C1_7 [CondMat1_3, surface CondMat1_3_surface] = rectangle(corner=(0mm, -21.45mm, -0.05mm), y_size=7.03333mm, z_size=0.1mm)
  C1_7.sweep_around_axis(axis=Z, angle=90deg, segments=15)
  C1_7.move(25.4mm, -5.1mm, 4.65mm)
  ToolC1_7_1 = box(corner=(46.85mm, -5.1mm, 4.6mm), size=(-7.03333mm, 10.2mm, 0.1mm))
  ToolC1_7_2 = rectangle(corner=(21.45mm, 0mm, -0.05mm), z_size=0.1mm, x_size=-7.03333mm)
  ToolC1_7_2.sweep_around_axis(axis=Z, angle=90deg, segments=15)
  ToolC1_7_2.move(25.4mm, 5.1mm, 4.65mm)
  ToolC1_7_3 = box(corner=(25.4mm, 26.55mm, 4.6mm), size=(-50.8mm, -7.03333mm, 0.1mm))
  ToolC1_7_4 = rectangle(corner=(0mm, 21.45mm, -0.05mm), y_size=-7.03333mm, z_size=0.1mm)
  ToolC1_7_4.sweep_around_axis(axis=Z, angle=90deg, segments=15)
  ToolC1_7_4.move(-25.4mm, 5.1mm, 4.65mm)
  ToolC1_7_5 = box(corner=(-46.85mm, 5.1mm, 4.6mm), size=(7.03333mm, -10.2mm, 0.1mm))
  ToolC1_7_6 = rectangle(corner=(-21.45mm, 0mm, -0.05mm), z_size=0.1mm, x_size=7.03333mm)
  ToolC1_7_6.sweep_around_axis(axis=Z, angle=90deg, segments=15)
  ToolC1_7_6.move(-25.4mm, -5.1mm, 4.65mm)
  ToolC1_7_7 = box(corner=(-25.4mm, -26.55mm, 4.6mm), size=(50.8mm, 7.03333mm, 0.1mm))
  C1_7.unite(ToolC1_7_1..ToolC1_7_7)
  C1_12 [CondMat1_4, surface CondMat1_4_surface] = rectangle(corner=(0mm, -7.28333mm, -0.05mm), y_size=7.03333mm, z_size=0.1mm)
  C1_12.sweep_around_axis(axis=Z, angle=90deg, segments=15)
  C1_12.move(25.4mm, -5.1mm, 4.45mm)
  ToolC1_12_1 = box(corner=(32.68333mm, -5.1mm, 4.4mm), size=(-7.03333mm, 10.2mm, 0.1mm))
  ToolC1_12_2 = rectangle(corner=(7.28333mm, 0mm, -0.05mm), z_size=0.1mm, x_size=-7.03333mm)
  ToolC1_12_2.sweep_around_axis(axis=Z, angle=90deg, segments=15)
  ToolC1_12_2.move(25.4mm, 5.1mm, 4.45mm)
  ToolC1_12_3 = box(corner=(25.4mm, 12.38333mm, 4.4mm), size=(-50.8mm, -7.03333mm, 0.1mm))
  ToolC1_12_4 = rectangle(corner=(0mm, 7.28333mm, -0.05mm), y_size=-7.03333mm, z_size=0.1mm)
  ToolC1_12_4.sweep_around_axis(axis=Z, angle=90deg, segments=15)
  ToolC1_12_4.move(-25.4mm, 5.1mm, 4.45mm)
  ToolC1_12_5 = box(corner=(-32.68333mm, 5.1mm, 4.4mm), size=(7.03333mm, -10.2mm, 0.1mm))
  ToolC1_12_6 = rectangle(corner=(-7.28333mm, 0mm, -0.05mm), z_size=0.1mm, x_size=7.03333mm)
  ToolC1_12_6.sweep_around_axis(axis=Z, angle=90deg, segments=15)
  ToolC1_12_6.move(-25.4mm, -5.1mm, 4.45mm)
  ToolC1_12_7 = box(corner=(-25.4mm, -12.38333mm, 4.4mm), size=(50.8mm, 7.03333mm, 0.1mm))
  C1_12.unite(ToolC1_12_1..ToolC1_12_7)
  C1_11 [CondMat1_4, surface CondMat1_4_surface] = rectangle(corner=(0mm, -14.36666mm, -0.05mm), y_size=7.03333mm, z_size=0.1mm)
  C1_11.sweep_around_axis(axis=Z, angle=90deg, segments=15)
  C1_11.move(25.4mm, -5.1mm, 4.45mm)
  ToolC1_11_1 = box(corner=(39.76666mm, -5.1mm, 4.4mm), size=(-7.03333mm, 10.2mm, 0.1mm))
  ToolC1_11_2 = rectangle(corner=(14.36666mm, 0mm, -0.05mm), z_size=0.1mm, x_size=-7.03333mm)
  ToolC1_11_2.sweep_around_axis(axis=Z, angle=90deg, segments=15)
  ToolC1_11_2.move(25.4mm, 5.1mm, 4.45mm)
  ToolC1_11_3 = box(corner=(25.4mm, 19.46666mm, 4.4mm), size=(-50.8mm, -7.03333mm, 0.1mm))
  ToolC1_11_4 = rectangle(corner=(0mm, 14.36666mm, -0.05mm), y_size=-7.03333mm, z_size=0.1mm)
  ToolC1_11_4.sweep_around_axis(axis=Z, angle=90deg, segments=15)
  ToolC1_11_4.move(-25.4mm, 5.1mm, 4.45mm)
  ToolC1_11_5 = box(corner=(-39.76666mm, 5.1mm, 4.4mm), size=(7.03333mm, -10.2mm, 0.1mm))
  ToolC1_11_6 = rectangle(corner=(-14.36666mm, 0mm, -0.05mm), z_size=0.1mm, x_size=7.03333mm)
  ToolC1_11_6.sweep_around_axis(axis=Z, angle=90deg, segments=15)
  ToolC1_11_6.move(-25.4mm, -5.1mm, 4.45mm)
  ToolC1_11_7 = box(corner=(-25.4mm, -19.46666mm, 4.4mm), size=(50.8mm, 7.03333mm, 0.1mm))
  C1_11.unite(ToolC1_11_1..ToolC1_11_7)
  C1_10 [CondMat1_4, surface CondMat1_4_surface] = rectangle(corner=(0mm, -21.45mm, -0.05mm), y_size=7.03333mm, z_size=0.1mm)
  C1_10.sweep_around_axis(axis=Z, angle=90deg, segments=15)
  C1_10.move(25.4mm, -5.1mm, 4.45mm)
  ToolC1_10_1 = box(corner=(46.85mm, -5.1mm, 4.4mm), size=(-7.03333mm, 10.2mm, 0.1mm))
  ToolC1_10_2 = rectangle(corner=(21.45mm, 0mm, -0.05mm), z_size=0.1mm, x_size=-7.03333mm)
  ToolC1_10_2.sweep_around_axis(axis=Z, angle=90deg, segments=15)
  ToolC1_10_2.move(25.4mm, 5.1mm, 4.45mm)
  ToolC1_10_3 = box(corner=(25.4mm, 26.55mm, 4.4mm), size=(-50.8mm, -7.03333mm, 0.1mm))
  ToolC1_10_4 = rectangle(corner=(0mm, 21.45mm, -0.05mm), y_size=-7.03333mm, z_size=0.1mm)
  ToolC1_10_4.sweep_around_axis(axis=Z, angle=90deg, segments=15)
  ToolC1_10_4.move(-25.4mm, 5.1mm, 4.45mm)
  ToolC1_10_5 = box(corner=(-46.85mm, 5.1mm, 4.4mm), size=(7.03333mm, -10.2mm, 0.1mm))
  ToolC1_10_6 = rectangle(corner=(-21.45mm, 0mm, -0.05mm), z_size=0.1mm, x_size=7.03333mm)
  ToolC1_10_6.sweep_around_axis(axis=Z, angle=90deg, segments=15)
  ToolC1_10_6.move(-25.4mm, -5.1mm, 4.45mm)
  ToolC1_10_7 = box(corner=(-25.4mm, -26.55mm, 4.4mm), size=(50.8mm, 7.03333mm, 0.1mm))
  C1_10.unite(ToolC1_10_1..ToolC1_10_7)
  C1_15 [CondMat1_5, surface CondMat1_5_surface] = rectangle(corner=(0mm, -7.28333mm, -0.05mm), y_size=7.03333mm, z_size=0.1mm)
  C1_15.sweep_around_axis(axis=Z, angle=90deg, segments=15)
  C1_15.move(25.4mm, -5.1mm, 4.25mm)
  ToolC1_15_1 = box(corner=(32.68333mm, -5.1mm, 4.2mm), size=(-7.03333mm, 10.2mm, 0.1mm))
  ToolC1_15_2 = rectangle(corner=(7.28333mm, 0mm, -0.05mm), z_size=0.1mm, x_size=-7.03333mm)
  ToolC1_15_2.sweep_around_axis(axis=Z, angle=90deg, segments=15)
  ToolC1_15_2.move(25.4mm, 5.1mm, 4.25mm)
  ToolC1_15_3 = box(corner=(25.4mm, 12.38333mm, 4.2mm), size=(-50.8mm, -7.03333mm, 0.1mm))
  ToolC1_15_4 = rectangle(corner=(0mm, 7.28333mm, -0.05mm), y_size=-7.03333mm, z_size=0.1mm)
  ToolC1_15_4.sweep_around_axis(axis=Z, angle=90deg, segments=15)
  ToolC1_15_4.move(-25.4mm, 5.1mm, 4.25mm)
  ToolC1_15_5 = box(corner=(-32.68333mm, 5.1mm, 4.2mm), size=(7.03333mm, -10.2mm, 0.1mm))
  ToolC1_15_6 = rectangle(corner=(-7.28333mm, 0mm, -0.05mm), z_size=0.1mm, x_size=7.03333mm)
  ToolC1_15_6.sweep_around_axis(axis=Z, angle=90deg, segments=15)
  ToolC1_15_6.move(-25.4mm, -5.1mm, 4.25mm)
  ToolC1_15_7 = box(corner=(-25.4mm, -12.38333mm, 4.2mm), size=(50.8mm, 7.03333mm, 0.1mm))
  C1_15.unite(ToolC1_15_1..ToolC1_15_7)
  C1_14 [CondMat1_5, surface CondMat1_5_surface] = rectangle(corner=(0mm, -14.36666mm, -0.05mm), y_size=7.03333mm, z_size=0.1mm)
  C1_14.sweep_around_axis(axis=Z, angle=90deg, segments=15)
  C1_14.move(25.4mm, -5.1mm, 4.25mm)
  ToolC1_14_1 = box(corner=(39.76666mm, -5.1mm, 4.2mm), size=(-7.03333mm, 10.2mm, 0.1mm))
  ToolC1_14_2 = rectangle(corner=(14.36666mm, 0mm, -0.05mm), z_size=0.1mm, x_size=-7.03333mm)
  ToolC1_14_2.sweep_around_axis(axis=Z, angle=90deg, segments=15)
  ToolC1_14_2.move(25.4mm, 5.1mm, 4.25mm)
  ToolC1_14_3 = box(corner=(25.4mm, 19.46666mm, 4.2mm), size=(-50.8mm, -7.03333mm, 0.1mm))
  ToolC1_14_4 = rectangle(corner=(0mm, 14.36666mm, -0.05mm), y_size=-7.03333mm, z_size=0.1mm)
  ToolC1_14_4.sweep_around_axis(axis=Z, angle=90deg, segments=15)
  ToolC1_14_4.move(-25.4mm, 5.1mm, 4.25mm)
  ToolC1_14_5 = box(corner=(-39.76666mm, 5.1mm, 4.2mm), size=(7.03333mm, -10.2mm, 0.1mm))
  ToolC1_14_6 = rectangle(corner=(-14.36666mm, 0mm, -0.05mm), z_size=0.1mm, x_size=7.03333mm)
  ToolC1_14_6.sweep_around_axis(axis=Z, angle=90deg, segments=15)
  ToolC1_14_6.move(-25.4mm, -5.1mm, 4.25mm)
  ToolC1_14_7 = box(corner=(-25.4mm, -19.46666mm, 4.2mm), size=(50.8mm, 7.03333mm, 0.1mm))
  C1_14.unite(ToolC1_14_1..ToolC1_14_7)
  C1_13 [CondMat1_5, surface CondMat1_5_surface] = rectangle(corner=(0mm, -21.45mm, -0.05mm), y_size=7.03333mm, z_size=0.1mm)
  C1_13.sweep_around_axis(axis=Z, angle=90deg, segments=15)
  C1_13.move(25.4mm, -5.1mm, 4.25mm)
  ToolC1_13_1 = box(corner=(46.85mm, -5.1mm, 4.2mm), size=(-7.03333mm, 10.2mm, 0.1mm))
  ToolC1_13_2 = rectangle(corner=(21.45mm, 0mm, -0.05mm), z_size=0.1mm, x_size=-7.03333mm)
  ToolC1_13_2.sweep_around_axis(axis=Z, angle=90deg, segments=15)
  ToolC1_13_2.move(25.4mm, 5.1mm, 4.25mm)
  ToolC1_13_3 = box(corner=(25.4mm, 26.55mm, 4.2mm), size=(-50.8mm, -7.03333mm, 0.1mm))
  ToolC1_13_4 = rectangle(corner=(0mm, 21.45mm, -0.05mm), y_size=-7.03333mm, z_size=0.1mm)
  ToolC1_13_4.sweep_around_axis(axis=Z, angle=90deg, segments=15)
  ToolC1_13_4.move(-25.4mm, 5.1mm, 4.25mm)
  ToolC1_13_5 = box(corner=(-46.85mm, 5.1mm, 4.2mm), size=(7.03333mm, -10.2mm, 0.1mm))
  ToolC1_13_6 = rectangle(corner=(-21.45mm, 0mm, -0.05mm), z_size=0.1mm, x_size=7.03333mm)
  ToolC1_13_6.sweep_around_axis(axis=Z, angle=90deg, segments=15)
  ToolC1_13_6.move(-25.4mm, -5.1mm, 4.25mm)
  ToolC1_13_7 = box(corner=(-25.4mm, -26.55mm, 4.2mm), size=(50.8mm, 7.03333mm, 0.1mm))
  C1_13.unite(ToolC1_13_1..ToolC1_13_7)
  C1_18 [CondMat1_6, surface CondMat1_6_surface] = rectangle(corner=(0mm, -7.28333mm, -0.05mm), y_size=7.03333mm, z_size=0.1mm)
  C1_18.sweep_around_axis(axis=Z, angle=90deg, segments=15)
  C1_18.move(25.4mm, -5.1mm, 4.05mm)
  ToolC1_18_1 = box(corner=(32.68333mm, -5.1mm, 4mm), size=(-7.03333mm, 10.2mm, 0.1mm))
  ToolC1_18_2 = rectangle(corner=(7.28333mm, 0mm, -0.05mm), z_size=0.1mm, x_size=-7.03333mm)
  ToolC1_18_2.sweep_around_axis(axis=Z, angle=90deg, segments=15)
  ToolC1_18_2.move(25.4mm, 5.1mm, 4.05mm)
  ToolC1_18_3 = box(corner=(25.4mm, 12.38333mm, 4mm), size=(-50.8mm, -7.03333mm, 0.1mm))
  ToolC1_18_4 = rectangle(corner=(0mm, 7.28333mm, -0.05mm), y_size=-7.03333mm, z_size=0.1mm)
  ToolC1_18_4.sweep_around_axis(axis=Z, angle=90deg, segments=15)
  ToolC1_18_4.move(-25.4mm, 5.1mm, 4.05mm)
  ToolC1_18_5 = box(corner=(-32.68333mm, 5.1mm, 4mm), size=(7.03333mm, -10.2mm, 0.1mm))
  ToolC1_18_6 = rectangle(corner=(-7.28333mm, 0mm, -0.05mm), z_size=0.1mm, x_size=7.03333mm)
  ToolC1_18_6.sweep_around_axis(axis=Z, angle=90deg, segments=15)
  ToolC1_18_6.move(-25.4mm, -5.1mm, 4.05mm)
  ToolC1_18_7 = box(corner=(-25.4mm, -12.38333mm, 4mm), size=(50.8mm, 7.03333mm, 0.1mm))
  C1_18.unite(ToolC1_18_1..ToolC1_18_7)
  C1_17 [CondMat1_6, surface CondMat1_6_surface] = rectangle(corner=(0mm, -14.36666mm, -0.05mm), y_size=7.03333mm, z_size=0.1mm)
  C1_17.sweep_around_axis(axis=Z, angle=90deg, segments=15)
  C1_17.move(25.4mm, -5.1mm, 4.05mm)
  ToolC1_17_1 = box(corner=(39.76666mm, -5.1mm, 4mm), size=(-7.03333mm, 10.2mm, 0.1mm))
  ToolC1_17_2 = rectangle(corner=(14.36666mm, 0mm, -0.05mm), z_size=0.1mm, x_size=-7.03333mm)
  ToolC1_17_2.sweep_around_axis(axis=Z, angle=90deg, segments=15)
  ToolC1_17_2.move(25.4mm, 5.1mm, 4.05mm)
  ToolC1_17_3 = box(corner=(25.4mm, 19.46666mm, 4mm), size=(-50.8mm, -7.03333mm, 0.1mm))
  ToolC1_17_4 = rectangle(corner=(0mm, 14.36666mm, -0.05mm), y_size=-7.03333mm, z_size=0.1mm)
  ToolC1_17_4.sweep_around_axis(axis=Z, angle=90deg, segments=15)
  ToolC1_17_4.move(-25.4mm, 5.1mm, 4.05mm)
  ToolC1_17_5 = box(corner=(-39.76666mm, 5.1mm, 4mm), size=(7.03333mm, -10.2mm, 0.1mm))
  ToolC1_17_6 = rectangle(corner=(-14.36666mm, 0mm, -0.05mm), z_size=0.1mm, x_size=7.03333mm)
  ToolC1_17_6.sweep_around_axis(axis=Z, angle=90deg, segments=15)
  ToolC1_17_6.move(-25.4mm, -5.1mm, 4.05mm)
  ToolC1_17_7 = box(corner=(-25.4mm, -19.46666mm, 4mm), size=(50.8mm, 7.03333mm, 0.1mm))
  C1_17.unite(ToolC1_17_1..ToolC1_17_7)
  C1_16 [CondMat1_6, surface CondMat1_6_surface] = rectangle(corner=(0mm, -21.45mm, -0.05mm), y_size=7.03333mm, z_size=0.1mm)
  C1_16.sweep_around_axis(axis=Z, angle=90deg, segments=15)
  C1_16.move(25.4mm, -5.1mm, 4.05mm)
  ToolC1_16_1 = box(corner=(46.85mm, -5.1mm, 4mm), size=(-7.03333mm, 10.2mm, 0.1mm))
  ToolC1_16_2 = rectangle(corner=(21.45mm, 0mm, -0.05mm), z_size=0.1mm, x_size=-7.03333mm)
  ToolC1_16_2.sweep_around_axis(axis=Z, angle=90deg, segments=15)
  ToolC1_16_2.move(25.4mm, 5.1mm, 4.05mm)
  ToolC1_16_3 = box(corner=(25.4mm, 26.55mm, 4mm), size=(-50.8mm, -7.03333mm, 0.1mm))
  ToolC1_16_4 = rectangle(corner=(0mm, 21.45mm, -0.05mm), y_size=-7.03333mm, z_size=0.1mm)
  ToolC1_16_4.sweep_around_axis(axis=Z, angle=90deg, segments=15)
  ToolC1_16_4.move(-25.4mm, 5.1mm, 4.05mm)
  ToolC1_16_5 = box(corner=(-46.85mm, 5.1mm, 4mm), size=(7.03333mm, -10.2mm, 0.1mm))
  ToolC1_16_6 = rectangle(corner=(-21.45mm, 0mm, -0.05mm), z_size=0.1mm, x_size=7.03333mm)
  ToolC1_16_6.sweep_around_axis(axis=Z, angle=90deg, segments=15)
  ToolC1_16_6.move(-25.4mm, -5.1mm, 4.05mm)
  ToolC1_16_7 = box(corner=(-25.4mm, -26.55mm, 4mm), size=(50.8mm, 7.03333mm, 0.1mm))
  C1_16.unite(ToolC1_16_1..ToolC1_16_7)
  C2_3 [CondMat2_1, surface CondMat2_1_surface] = rectangle(corner=(0mm, -7.28333mm, -0.05mm), y_size=7.03333mm, z_size=0.1mm)
  C2_3.sweep_around_axis(axis=Z, angle=90deg, segments=15)
  C2_3.move(25.4mm, -5.1mm, 3.85mm)
  ToolC2_3_1 = box(corner=(32.68333mm, -5.1mm, 3.8mm), size=(-7.03333mm, 10.2mm, 0.1mm))
  ToolC2_3_2 = rectangle(corner=(7.28333mm, 0mm, -0.05mm), z_size=0.1mm, x_size=-7.03333mm)
  ToolC2_3_2.sweep_around_axis(axis=Z, angle=90deg, segments=15)
  ToolC2_3_2.move(25.4mm, 5.1mm, 3.85mm)
  ToolC2_3_3 = box(corner=(25.4mm, 12.38333mm, 3.8mm), size=(-50.8mm, -7.03333mm, 0.1mm))
  ToolC2_3_4 = rectangle(corner=(0mm, 7.28333mm, -0.05mm), y_size=-7.03333mm, z_size=0.1mm)
  ToolC2_3_4.sweep_around_axis(axis=Z, angle=90deg, segments=15)
  ToolC2_3_4.move(-25.4mm, 5.1mm, 3.85mm)
  ToolC2_3_5 = box(corner=(-32.68333mm, 5.1mm, 3.8mm), size=(7.03333mm, -10.2mm, 0.1mm))
  ToolC2_3_6 = rectangle(corner=(-7.28333mm, 0mm, -0.05mm), z_size=0.1mm, x_size=7.03333mm)
  ToolC2_3_6.sweep_around_axis(axis=Z, angle=90deg, segments=15)
  ToolC2_3_6.move(-25.4mm, -5.1mm, 3.85mm)
  ToolC2_3_7 = box(corner=(-25.4mm, -12.38333mm, 3.8mm), size=(50.8mm, 7.03333mm, 0.1mm))
  C2_3.unite(ToolC2_3_1..ToolC2_3_7)
  C2_2 [CondMat2_1, surface CondMat2_1_surface] = rectangle(corner=(0mm, -14.36666mm, -0.05mm), y_size=7.03333mm, z_size=0.1mm)
  C2_2.sweep_around_axis(axis=Z, angle=90deg, segments=15)
  C2_2.move(25.4mm, -5.1mm, 3.85mm)
  ToolC2_2_1 = box(corner=(39.76666mm, -5.1mm, 3.8mm), size=(-7.03333mm, 10.2mm, 0.1mm))
  ToolC2_2_2 = rectangle(corner=(14.36666mm, 0mm, -0.05mm), z_size=0.1mm, x_size=-7.03333mm)
  ToolC2_2_2.sweep_around_axis(axis=Z, angle=90deg, segments=15)
  ToolC2_2_2.move(25.4mm, 5.1mm, 3.85mm)
  ToolC2_2_3 = box(corner=(25.4mm, 19.46666mm, 3.8mm), size=(-50.8mm, -7.03333mm, 0.1mm))
  ToolC2_2_4 = rectangle(corner=(0mm, 14.36666mm, -0.05mm), y_size=-7.03333mm, z_size=0.1mm)
  ToolC2_2_4.sweep_around_axis(axis=Z, angle=90deg, segments=15)
  ToolC2_2_4.move(-25.4mm, 5.1mm, 3.85mm)
  ToolC2_2_5 = box(corner=(-39.76666mm, 5.1mm, 3.8mm), size=(7.03333mm, -10.2mm, 0.1mm))
  ToolC2_2_6 = rectangle(corner=(-14.36666mm, 0mm, -0.05mm), z_size=0.1mm, x_size=7.03333mm)
  ToolC2_2_6.sweep_around_axis(axis=Z, angle=90deg, segments=15)
  ToolC2_2_6.move(-25.4mm, -5.1mm, 3.85mm)
  ToolC2_2_7 = box(corner=(-25.4mm, -19.46666mm, 3.8mm), size=(50.8mm, 7.03333mm, 0.1mm))
  C2_2.unite(ToolC2_2_1..ToolC2_2_7)
  C2_1 [CondMat2_1, surface CondMat2_1_surface] = rectangle(corner=(0mm, -21.45mm, -0.05mm), y_size=7.03333mm, z_size=0.1mm)
  C2_1.sweep_around_axis(axis=Z, angle=90deg, segments=15)
  C2_1.move(25.4mm, -5.1mm, 3.85mm)
  ToolC2_1_1 = box(corner=(46.85mm, -5.1mm, 3.8mm), size=(-7.03333mm, 10.2mm, 0.1mm))
  ToolC2_1_2 = rectangle(corner=(21.45mm, 0mm, -0.05mm), z_size=0.1mm, x_size=-7.03333mm)
  ToolC2_1_2.sweep_around_axis(axis=Z, angle=90deg, segments=15)
  ToolC2_1_2.move(25.4mm, 5.1mm, 3.85mm)
  ToolC2_1_3 = box(corner=(25.4mm, 26.55mm, 3.8mm), size=(-50.8mm, -7.03333mm, 0.1mm))
  ToolC2_1_4 = rectangle(corner=(0mm, 21.45mm, -0.05mm), y_size=-7.03333mm, z_size=0.1mm)
  ToolC2_1_4.sweep_around_axis(axis=Z, angle=90deg, segments=15)
  ToolC2_1_4.move(-25.4mm, 5.1mm, 3.85mm)
  ToolC2_1_5 = box(corner=(-46.85mm, 5.1mm, 3.8mm), size=(7.03333mm, -10.2mm, 0.1mm))
  ToolC2_1_6 = rectangle(corner=(-21.45mm, 0mm, -0.05mm), z_size=0.1mm, x_size=7.03333mm)
  ToolC2_1_6.sweep_around_axis(axis=Z, angle=90deg, segments=15)
  ToolC2_1_6.move(-25.4mm, -5.1mm, 3.85mm)
  ToolC2_1_7 = box(corner=(-25.4mm, -26.55mm, 3.8mm), size=(50.8mm, 7.03333mm, 0.1mm))
  C2_1.unite(ToolC2_1_1..ToolC2_1_7)
  C2_6 [CondMat2_2, surface CondMat2_2_surface] = rectangle(corner=(0mm, -7.28333mm, -0.05mm), y_size=7.03333mm, z_size=0.1mm)
  C2_6.sweep_around_axis(axis=Z, angle=90deg, segments=15)
  C2_6.move(25.4mm, -5.1mm, 3.65mm)
  ToolC2_6_1 = box(corner=(32.68333mm, -5.1mm, 3.6mm), size=(-7.03333mm, 10.2mm, 0.1mm))
  ToolC2_6_2 = rectangle(corner=(7.28333mm, 0mm, -0.05mm), z_size=0.1mm, x_size=-7.03333mm)
  ToolC2_6_2.sweep_around_axis(axis=Z, angle=90deg, segments=15)
  ToolC2_6_2.move(25.4mm, 5.1mm, 3.65mm)
  ToolC2_6_3 = box(corner=(25.4mm, 12.38333mm, 3.6mm), size=(-50.8mm, -7.03333mm, 0.1mm))
  ToolC2_6_4 = rectangle(corner=(0mm, 7.28333mm, -0.05mm), y_size=-7.03333mm, z_size=0.1mm)
  ToolC2_6_4.sweep_around_axis(axis=Z, angle=90deg, segments=15)
  ToolC2_6_4.move(-25.4mm, 5.1mm, 3.65mm)
  ToolC2_6_5 = box(corner=(-32.68333mm, 5.1mm, 3.6mm), size=(7.03333mm, -10.2mm, 0.1mm))
  ToolC2_6_6 = rectangle(corner=(-7.28333mm, 0mm, -0.05mm), z_size=0.1mm, x_size=7.03333mm)
  ToolC2_6_6.sweep_around_axis(axis=Z, angle=90deg, segments=15)
  ToolC2_6_6.move(-25.4mm, -5.1mm, 3.65mm)
  ToolC2_6_7 = box(corner=(-25.4mm, -12.38333mm, 3.6mm), size=(50.8mm, 7.03333mm, 0.1mm))
  C2_6.unite(ToolC2_6_1..ToolC2_6_7)
  C2_5 [CondMat2_2, surface CondMat2_2_surface] = rectangle(corner=(0mm, -14.36666mm, -0.05mm), y_size=7.03333mm, z_size=0.1mm)
  C2_5.sweep_around_axis(axis=Z, angle=90deg, segments=15)
  C2_5.move(25.4mm, -5.1mm, 3.65mm)
  ToolC2_5_1 = box(corner=(39.76666mm, -5.1mm, 3.6mm), size=(-7.03333mm, 10.2mm, 0.1mm))
  ToolC2_5_2 = rectangle(corner=(14.36666mm, 0mm, -0.05mm), z_size=0.1mm, x_size=-7.03333mm)
  ToolC2_5_2.sweep_around_axis(axis=Z, angle=90deg, segments=15)
  ToolC2_5_2.move(25.4mm, 5.1mm, 3.65mm)
  ToolC2_5_3 = box(corner=(25.4mm, 19.46666mm, 3.6mm), size=(-50.8mm, -7.03333mm, 0.1mm))
  ToolC2_5_4 = rectangle(corner=(0mm, 14.36666mm, -0.05mm), y_size=-7.03333mm, z_size=0.1mm)
  ToolC2_5_4.sweep_around_axis(axis=Z, angle=90deg, segments=15)
  ToolC2_5_4.move(-25.4mm, 5.1mm, 3.65mm)
  ToolC2_5_5 = box(corner=(-39.76666mm, 5.1mm, 3.6mm), size=(7.03333mm, -10.2mm, 0.1mm))
  ToolC2_5_6 = rectangle(corner=(-14.36666mm, 0mm, -0.05mm), z_size=0.1mm, x_size=7.03333mm)
  ToolC2_5_6.sweep_around_axis(axis=Z, angle=90deg, segments=15)
  ToolC2_5_6.move(-25.4mm, -5.1mm, 3.65mm)
  ToolC2_5_7 = box(corner=(-25.4mm, -19.46666mm, 3.6mm), size=(50.8mm, 7.03333mm, 0.1mm))
  C2_5.unite(ToolC2_5_1..ToolC2_5_7)
  C2_4 [CondMat2_2, surface CondMat2_2_surface] = rectangle(corner=(0mm, -21.45mm, -0.05mm), y_size=7.03333mm, z_size=0.1mm)
  C2_4.sweep_around_axis(axis=Z, angle=90deg, segments=15)
  C2_4.move(25.4mm, -5.1mm, 3.65mm)
  ToolC2_4_1 = box(corner=(46.85mm, -5.1mm, 3.6mm), size=(-7.03333mm, 10.2mm, 0.1mm))
  ToolC2_4_2 = rectangle(corner=(21.45mm, 0mm, -0.05mm), z_size=0.1mm, x_size=-7.03333mm)
  ToolC2_4_2.sweep_around_axis(axis=Z, angle=90deg, segments=15)
  ToolC2_4_2.move(25.4mm, 5.1mm, 3.65mm)
  ToolC2_4_3 = box(corner=(25.4mm, 26.55mm, 3.6mm), size=(-50.8mm, -7.03333mm, 0.1mm))
  ToolC2_4_4 = rectangle(corner=(0mm, 21.45mm, -0.05mm), y_size=-7.03333mm, z_size=0.1mm)
  ToolC2_4_4.sweep_around_axis(axis=Z, angle=90deg, segments=15)
  ToolC2_4_4.move(-25.4mm, 5.1mm, 3.65mm)
  ToolC2_4_5 = box(corner=(-46.85mm, 5.1mm, 3.6mm), size=(7.03333mm, -10.2mm, 0.1mm))
  ToolC2_4_6 = rectangle(corner=(-21.45mm, 0mm, -0.05mm), z_size=0.1mm, x_size=7.03333mm)
  ToolC2_4_6.sweep_around_axis(axis=Z, angle=90deg, segments=15)
  ToolC2_4_6.move(-25.4mm, -5.1mm, 3.65mm)
  ToolC2_4_7 = box(corner=(-25.4mm, -26.55mm, 3.6mm), size=(50.8mm, 7.03333mm, 0.1mm))
  C2_4.unite(ToolC2_4_1..ToolC2_4_7)
  C2_9 [CondMat2_3, surface CondMat2_3_surface] = rectangle(corner=(0mm, -7.28333mm, -0.05mm), y_size=7.03333mm, z_size=0.1mm)
  C2_9.sweep_around_axis(axis=Z, angle=90deg, segments=15)
  C2_9.move(25.4mm, -5.1mm, 3.45mm)
  ToolC2_9_1 = box(corner=(32.68333mm, -5.1mm, 3.4mm), size=(-7.03333mm, 10.2mm, 0.1mm))
  ToolC2_9_2 = rectangle(corner=(7.28333mm, 0mm, -0.05mm), z_size=0.1mm, x_size=-7.03333mm)
  ToolC2_9_2.sweep_around_axis(axis=Z, angle=90deg, segments=15)
  ToolC2_9_2.move(25.4mm, 5.1mm, 3.45mm)
  ToolC2_9_3 = box(corner=(25.4mm, 12.38333mm, 3.4mm), size=(-50.8mm, -7.03333mm, 0.1mm))
  ToolC2_9_4 = rectangle(corner=(0mm, 7.28333mm, -0.05mm), y_size=-7.03333mm, z_size=0.1mm)
  ToolC2_9_4.sweep_around_axis(axis=Z, angle=90deg, segments=15)
  ToolC2_9_4.move(-25.4mm, 5.1mm, 3.45mm)
  ToolC2_9_5 = box(corner=(-32.68333mm, 5.1mm, 3.4mm), size=(7.03333mm, -10.2mm, 0.1mm))
  ToolC2_9_6 = rectangle(corner=(-7.28333mm, 0mm, -0.05mm), z_size=0.1mm, x_size=7.03333mm)
  ToolC2_9_6.sweep_around_axis(axis=Z, angle=90deg, segments=15)
  ToolC2_9_6.move(-25.4mm, -5.1mm, 3.45mm)
  ToolC2_9_7 = box(corner=(-25.4mm, -12.38333mm, 3.4mm), size=(50.8mm, 7.03333mm, 0.1mm))
  C2_9.unite(ToolC2_9_1..ToolC2_9_7)
  C2_8 [CondMat2_3, surface CondMat2_3_surface] = rectangle(corner=(0mm, -14.36666mm, -0.05mm), y_size=7.03333mm, z_size=0.1mm)
  C2_8.sweep_around_axis(axis=Z, angle=90deg, segments=15)
  C2_8.move(25.4mm, -5.1mm, 3.45mm)
  ToolC2_8_1 = box(corner=(39.76666mm, -5.1mm, 3.4mm), size=(-7.03333mm, 10.2mm, 0.1mm))
  ToolC2_8_2 = rectangle(corner=(14.36666mm, 0mm, -0.05mm), z_size=0.1mm, x_size=-7.03333mm)
  ToolC2_8_2.sweep_around_axis(axis=Z, angle=90deg, segments=15)
  ToolC2_8_2.move(25.4mm, 5.1mm, 3.45mm)
  ToolC2_8_3 = box(corner=(25.4mm, 19.46666mm, 3.4mm), size=(-50.8mm, -7.03333mm, 0.1mm))
  ToolC2_8_4 = rectangle(corner=(0mm, 14.36666mm, -0.05mm), y_size=-7.03333mm, z_size=0.1mm)
  ToolC2_8_4.sweep_around_axis(axis=Z, angle=90deg, segments=15)
  ToolC2_8_4.move(-25.4mm, 5.1mm, 3.45mm)
  ToolC2_8_5 = box(corner=(-39.76666mm, 5.1mm, 3.4mm), size=(7.03333mm, -10.2mm, 0.1mm))
  ToolC2_8_6 = rectangle(corner=(-14.36666mm, 0mm, -0.05mm), z_size=0.1mm, x_size=7.03333mm)
  ToolC2_8_6.sweep_around_axis(axis=Z, angle=90deg, segments=15)
  ToolC2_8_6.move(-25.4mm, -5.1mm, 3.45mm)
  ToolC2_8_7 = box(corner=(-25.4mm, -19.46666mm, 3.4mm), size=(50.8mm, 7.03333mm, 0.1mm))
  C2_8.unite(ToolC2_8_1..ToolC2_8_7)
  C2_7 [CondMat2_3, surface CondMat2_3_surface] = rectangle(corner=(0mm, -21.45mm, -0.05mm), y_size=7.03333mm, z_size=0.1mm)
  C2_7.sweep_around_axis(axis=Z, angle=90deg, segments=15)
  C2_7.move(25.4mm, -5.1mm, 3.45mm)
  ToolC2_7_1 = box(corner=(46.85mm, -5.1mm, 3.4mm), size=(-7.03333mm, 10.2mm, 0.1mm))
  ToolC2_7_2 = rectangle(corner=(21.45mm, 0mm, -0.05mm), z_size=0.1mm, x_size=-7.03333mm)
  ToolC2_7_2.sweep_around_axis(axis=Z, angle=90deg, segments=15)
  ToolC2_7_2.move(25.4mm, 5.1mm, 3.45mm)
  ToolC2_7_3 = box(corner=(25.4mm, 26.55mm, 3.4mm), size=(-50.8mm, -7.03333mm, 0.1mm))
  ToolC2_7_4 = rectangle(corner=(0mm, 21.45mm, -0.05mm), y_size=-7.03333mm, z_size=0.1mm)
  ToolC2_7_4.sweep_around_axis(axis=Z, angle=90deg, segments=15)
  ToolC2_7_4.move(-25.4mm, 5.1mm, 3.45mm)
  ToolC2_7_5 = box(corner=(-46.85mm, 5.1mm, 3.4mm), size=(7.03333mm, -10.2mm, 0.1mm))
  ToolC2_7_6 = rectangle(corner=(-21.45mm, 0mm, -0.05mm), z_size=0.1mm, x_size=7.03333mm)
  ToolC2_7_6.sweep_around_axis(axis=Z, angle=90deg, segments=15)
  ToolC2_7_6.move(-25.4mm, -5.1mm, 3.45mm)
  ToolC2_7_7 = box(corner=(-25.4mm, -26.55mm, 3.4mm), size=(50.8mm, 7.03333mm, 0.1mm))
  C2_7.unite(ToolC2_7_1..ToolC2_7_7)
  C2_12 [CondMat2_4, surface CondMat2_4_surface] = rectangle(corner=(0mm, -7.28333mm, -0.05mm), y_size=7.03333mm, z_size=0.1mm)
  C2_12.sweep_around_axis(axis=Z, angle=90deg, segments=15)
  C2_12.move(25.4mm, -5.1mm, 3.25mm)
  ToolC2_12_1 = box(corner=(32.68333mm, -5.1mm, 3.2mm), size=(-7.03333mm, 10.2mm, 0.1mm))
  ToolC2_12_2 = rectangle(corner=(7.28333mm, 0mm, -0.05mm), z_size=0.1mm, x_size=-7.03333mm)
  ToolC2_12_2.sweep_around_axis(axis=Z, angle=90deg, segments=15)
  ToolC2_12_2.move(25.4mm, 5.1mm, 3.25mm)
  ToolC2_12_3 = box(corner=(25.4mm, 12.38333mm, 3.2mm), size=(-50.8mm, -7.03333mm, 0.1mm))
  ToolC2_12_4 = rectangle(corner=(0mm, 7.28333mm, -0.05mm), y_size=-7.03333mm, z_size=0.1mm)
  ToolC2_12_4.sweep_around_axis(axis=Z, angle=90deg, segments=15)
  ToolC2_12_4.move(-25.4mm, 5.1mm, 3.25mm)
  ToolC2_12_5 = box(corner=(-32.68333mm, 5.1mm, 3.2mm), size=(7.03333mm, -10.2mm, 0.1mm))
  ToolC2_12_6 = rectangle(corner=(-7.28333mm, 0mm, -0.05mm), z_size=0.1mm, x_size=7.03333mm)
  ToolC2_12_6.sweep_around_axis(axis=Z, angle=90deg, segments=15)
  ToolC2_12_6.move(-25.4mm, -5.1mm, 3.25mm)
  ToolC2_12_7 = box(corner=(-25.4mm, -12.38333mm, 3.2mm), size=(50.8mm, 7.03333mm, 0.1mm))
  C2_12.unite(ToolC2_12_1..ToolC2_12_7)
  C2_11 [CondMat2_4, surface CondMat2_4_surface] = rectangle(corner=(0mm, -14.36666mm, -0.05mm), y_size=7.03333mm, z_size=0.1mm)
  C2_11.sweep_around_axis(axis=Z, angle=90deg, segments=15)
  C2_11.move(25.4mm, -5.1mm, 3.25mm)
  ToolC2_11_1 = box(corner=(39.76666mm, -5.1mm, 3.2mm), size=(-7.03333mm, 10.2mm, 0.1mm))
  ToolC2_11_2 = rectangle(corner=(14.36666mm, 0mm, -0.05mm), z_size=0.1mm, x_size=-7.03333mm)
  ToolC2_11_2.sweep_around_axis(axis=Z, angle=90deg, segments=15)
  ToolC2_11_2.move(25.4mm, 5.1mm, 3.25mm)
  ToolC2_11_3 = box(corner=(25.4mm, 19.46666mm, 3.2mm), size=(-50.8mm, -7.03333mm, 0.1mm))
  ToolC2_11_4 = rectangle(corner=(0mm, 14.36666mm, -0.05mm), y_size=-7.03333mm, z_size=0.1mm)
  ToolC2_11_4.sweep_around_axis(axis=Z, angle=90deg, segments=15)
  ToolC2_11_4.move(-25.4mm, 5.1mm, 3.25mm)
  ToolC2_11_5 = box(corner=(-39.76666mm, 5.1mm, 3.2mm), size=(7.03333mm, -10.2mm, 0.1mm))
  ToolC2_11_6 = rectangle(corner=(-14.36666mm, 0mm, -0.05mm), z_size=0.1mm, x_size=7.03333mm)
  ToolC2_11_6.sweep_around_axis(axis=Z, angle=90deg, segments=15)
  ToolC2_11_6.move(-25.4mm, -5.1mm, 3.25mm)
  ToolC2_11_7 = box(corner=(-25.4mm, -19.46666mm, 3.2mm), size=(50.8mm, 7.03333mm, 0.1mm))
  C2_11.unite(ToolC2_11_1..ToolC2_11_7)
  C2_10 [CondMat2_4, surface CondMat2_4_surface] = rectangle(corner=(0mm, -21.45mm, -0.05mm), y_size=7.03333mm, z_size=0.1mm)
  C2_10.sweep_around_axis(axis=Z, angle=90deg, segments=15)
  C2_10.move(25.4mm, -5.1mm, 3.25mm)
  ToolC2_10_1 = box(corner=(46.85mm, -5.1mm, 3.2mm), size=(-7.03333mm, 10.2mm, 0.1mm))
  ToolC2_10_2 = rectangle(corner=(21.45mm, 0mm, -0.05mm), z_size=0.1mm, x_size=-7.03333mm)
  ToolC2_10_2.sweep_around_axis(axis=Z, angle=90deg, segments=15)
  ToolC2_10_2.move(25.4mm, 5.1mm, 3.25mm)
  ToolC2_10_3 = box(corner=(25.4mm, 26.55mm, 3.2mm), size=(-50.8mm, -7.03333mm, 0.1mm))
  ToolC2_10_4 = rectangle(corner=(0mm, 21.45mm, -0.05mm), y_size=-7.03333mm, z_size=0.1mm)
  ToolC2_10_4.sweep_around_axis(axis=Z, angle=90deg, segments=15)
  ToolC2_10_4.move(-25.4mm, 5.1mm, 3.25mm)
  ToolC2_10_5 = box(corner=(-46.85mm, 5.1mm, 3.2mm), size=(7.03333mm, -10.2mm, 0.1mm))
  ToolC2_10_6 = rectangle(corner=(-21.45mm, 0mm, -0.05mm), z_size=0.1mm, x_size=7.03333mm)
  ToolC2_10_6.sweep_around_axis(axis=Z, angle=90deg, segments=15)
  ToolC2_10_6.move(-25.4mm, -5.1mm, 3.25mm)
  ToolC2_10_7 = box(corner=(-25.4mm, -26.55mm, 3.2mm), size=(50.8mm, 7.03333mm, 0.1mm))
  C2_10.unite(ToolC2_10_1..ToolC2_10_7)
  C2_15 [CondMat2_5, surface CondMat2_5_surface] = rectangle(corner=(0mm, -7.28333mm, -0.05mm), y_size=7.03333mm, z_size=0.1mm)
  C2_15.sweep_around_axis(axis=Z, angle=90deg, segments=15)
  C2_15.move(25.4mm, -5.1mm, 3.05mm)
  ToolC2_15_1 = box(corner=(32.68333mm, -5.1mm, 3mm), size=(-7.03333mm, 10.2mm, 0.1mm))
  ToolC2_15_2 = rectangle(corner=(7.28333mm, 0mm, -0.05mm), z_size=0.1mm, x_size=-7.03333mm)
  ToolC2_15_2.sweep_around_axis(axis=Z, angle=90deg, segments=15)
  ToolC2_15_2.move(25.4mm, 5.1mm, 3.05mm)
  ToolC2_15_3 = box(corner=(25.4mm, 12.38333mm, 3mm), size=(-50.8mm, -7.03333mm, 0.1mm))
  ToolC2_15_4 = rectangle(corner=(0mm, 7.28333mm, -0.05mm), y_size=-7.03333mm, z_size=0.1mm)
  ToolC2_15_4.sweep_around_axis(axis=Z, angle=90deg, segments=15)
  ToolC2_15_4.move(-25.4mm, 5.1mm, 3.05mm)
  ToolC2_15_5 = box(corner=(-32.68333mm, 5.1mm, 3mm), size=(7.03333mm, -10.2mm, 0.1mm))
  ToolC2_15_6 = rectangle(corner=(-7.28333mm, 0mm, -0.05mm), z_size=0.1mm, x_size=7.03333mm)
  ToolC2_15_6.sweep_around_axis(axis=Z, angle=90deg, segments=15)
  ToolC2_15_6.move(-25.4mm, -5.1mm, 3.05mm)
  ToolC2_15_7 = box(corner=(-25.4mm, -12.38333mm, 3mm), size=(50.8mm, 7.03333mm, 0.1mm))
  C2_15.unite(ToolC2_15_1..ToolC2_15_7)
  C2_14 [CondMat2_5, surface CondMat2_5_surface] = rectangle(corner=(0mm, -14.36666mm, -0.05mm), y_size=7.03333mm, z_size=0.1mm)
  C2_14.sweep_around_axis(axis=Z, angle=90deg, segments=15)
  C2_14.move(25.4mm, -5.1mm, 3.05mm)
  ToolC2_14_1 = box(corner=(39.76666mm, -5.1mm, 3mm), size=(-7.03333mm, 10.2mm, 0.1mm))
  ToolC2_14_2 = rectangle(corner=(14.36666mm, 0mm, -0.05mm), z_size=0.1mm, x_size=-7.03333mm)
  ToolC2_14_2.sweep_around_axis(axis=Z, angle=90deg, segments=15)
  ToolC2_14_2.move(25.4mm, 5.1mm, 3.05mm)
  ToolC2_14_3 = box(corner=(25.4mm, 19.46666mm, 3mm), size=(-50.8mm, -7.03333mm, 0.1mm))
  ToolC2_14_4 = rectangle(corner=(0mm, 14.36666mm, -0.05mm), y_size=-7.03333mm, z_size=0.1mm)
  ToolC2_14_4.sweep_around_axis(axis=Z, angle=90deg, segments=15)
  ToolC2_14_4.move(-25.4mm, 5.1mm, 3.05mm)
  ToolC2_14_5 = box(corner=(-39.76666mm, 5.1mm, 3mm), size=(7.03333mm, -10.2mm, 0.1mm))
  ToolC2_14_6 = rectangle(corner=(-14.36666mm, 0mm, -0.05mm), z_size=0.1mm, x_size=7.03333mm)
  ToolC2_14_6.sweep_around_axis(axis=Z, angle=90deg, segments=15)
  ToolC2_14_6.move(-25.4mm, -5.1mm, 3.05mm)
  ToolC2_14_7 = box(corner=(-25.4mm, -19.46666mm, 3mm), size=(50.8mm, 7.03333mm, 0.1mm))
  C2_14.unite(ToolC2_14_1..ToolC2_14_7)
  C2_13 [CondMat2_5, surface CondMat2_5_surface] = rectangle(corner=(0mm, -21.45mm, -0.05mm), y_size=7.03333mm, z_size=0.1mm)
  C2_13.sweep_around_axis(axis=Z, angle=90deg, segments=15)
  C2_13.move(25.4mm, -5.1mm, 3.05mm)
  ToolC2_13_1 = box(corner=(46.85mm, -5.1mm, 3mm), size=(-7.03333mm, 10.2mm, 0.1mm))
  ToolC2_13_2 = rectangle(corner=(21.45mm, 0mm, -0.05mm), z_size=0.1mm, x_size=-7.03333mm)
  ToolC2_13_2.sweep_around_axis(axis=Z, angle=90deg, segments=15)
  ToolC2_13_2.move(25.4mm, 5.1mm, 3.05mm)
  ToolC2_13_3 = box(corner=(25.4mm, 26.55mm, 3mm), size=(-50.8mm, -7.03333mm, 0.1mm))
  ToolC2_13_4 = rectangle(corner=(0mm, 21.45mm, -0.05mm), y_size=-7.03333mm, z_size=0.1mm)
  ToolC2_13_4.sweep_around_axis(axis=Z, angle=90deg, segments=15)
  ToolC2_13_4.move(-25.4mm, 5.1mm, 3.05mm)
  ToolC2_13_5 = box(corner=(-46.85mm, 5.1mm, 3mm), size=(7.03333mm, -10.2mm, 0.1mm))
  ToolC2_13_6 = rectangle(corner=(-21.45mm, 0mm, -0.05mm), z_size=0.1mm, x_size=7.03333mm)
  ToolC2_13_6.sweep_around_axis(axis=Z, angle=90deg, segments=15)
  ToolC2_13_6.move(-25.4mm, -5.1mm, 3.05mm)
  ToolC2_13_7 = box(corner=(-25.4mm, -26.55mm, 3mm), size=(50.8mm, 7.03333mm, 0.1mm))
  C2_13.unite(ToolC2_13_1..ToolC2_13_7)
  C2_18 [CondMat2_6, surface CondMat2_6_surface] = rectangle(corner=(0mm, -7.28333mm, -0.05mm), y_size=7.03333mm, z_size=0.1mm)
  C2_18.sweep_around_axis(axis=Z, angle=90deg, segments=15)
  C2_18.move(25.4mm, -5.1mm, 2.85mm)
  ToolC2_18_1 = box(corner=(32.68333mm, -5.1mm, 2.8mm), size=(-7.03333mm, 10.2mm, 0.1mm))
  ToolC2_18_2 = rectangle(corner=(7.28333mm, 0mm, -0.05mm), z_size=0.1mm, x_size=-7.03333mm)
  ToolC2_18_2.sweep_around_axis(axis=Z, angle=90deg, segments=15)
  ToolC2_18_2.move(25.4mm, 5.1mm, 2.85mm)
  ToolC2_18_3 = box(corner=(25.4mm, 12.38333mm, 2.8mm), size=(-50.8mm, -7.03333mm, 0.1mm))
  ToolC2_18_4 = rectangle(corner=(0mm, 7.28333mm, -0.05mm), y_size=-7.03333mm, z_size=0.1mm)
  ToolC2_18_4.sweep_around_axis(axis=Z, angle=90deg, segments=15)
  ToolC2_18_4.move(-25.4mm, 5.1mm, 2.85mm)
  ToolC2_18_5 = box(corner=(-32.68333mm, 5.1mm, 2.8mm), size=(7.03333mm, -10.2mm, 0.1mm))
  ToolC2_18_6 = rectangle(corner=(-7.28333mm, 0mm, -0.05mm), z_size=0.1mm, x_size=7.03333mm)
  ToolC2_18_6.sweep_around_axis(axis=Z, angle=90deg, segments=15)
  ToolC2_18_6.move(-25.4mm, -5.1mm, 2.85mm)
  ToolC2_18_7 = box(corner=(-25.4mm, -12.38333mm, 2.8mm), size=(50.8mm, 7.03333mm, 0.1mm))
  C2_18.unite(ToolC2_18_1..ToolC2_18_7)
  C2_17 [CondMat2_6, surface CondMat2_6_surface] = rectangle(corner=(0mm, -14.36666mm, -0.05mm), y_size=7.03333mm, z_size=0.1mm)
  C2_17.sweep_around_axis(axis=Z, angle=90deg, segments=15)
  C2_17.move(25.4mm, -5.1mm, 2.85mm)
  ToolC2_17_1 = box(corner=(39.76666mm, -5.1mm, 2.8mm), size=(-7.03333mm, 10.2mm, 0.1mm))
  ToolC2_17_2 = rectangle(corner=(14.36666mm, 0mm, -0.05mm), z_size=0.1mm, x_size=-7.03333mm)
  ToolC2_17_2.sweep_around_axis(axis=Z, angle=90deg, segments=15)
  ToolC2_17_2.move(25.4mm, 5.1mm, 2.85mm)
  ToolC2_17_3 = box(corner=(25.4mm, 19.46666mm, 2.8mm), size=(-50.8mm, -7.03333mm, 0.1mm))
  ToolC2_17_4 = rectangle(corner=(0mm, 14.36666mm, -0.05mm), y_size=-7.03333mm, z_size=0.1mm)
  ToolC2_17_4.sweep_around_axis(axis=Z, angle=90deg, segments=15)
  ToolC2_17_4.move(-25.4mm, 5.1mm, 2.85mm)
  ToolC2_17_5 = box(corner=(-39.76666mm, 5.1mm, 2.8mm), size=(7.03333mm, -10.2mm, 0.1mm))
  ToolC2_17_6 = rectangle(corner=(-14.36666mm, 0mm, -0.05mm), z_size=0.1mm, x_size=7.03333mm)
  ToolC2_17_6.sweep_around_axis(axis=Z, angle=90deg, segments=15)
  ToolC2_17_6.move(-25.4mm, -5.1mm, 2.85mm)
  ToolC2_17_7 = box(corner=(-25.4mm, -19.46666mm, 2.8mm), size=(50.8mm, 7.03333mm, 0.1mm))
  C2_17.unite(ToolC2_17_1..ToolC2_17_7)
  C2_16 [CondMat2_6, surface CondMat2_6_surface] = rectangle(corner=(0mm, -21.45mm, -0.05mm), y_size=7.03333mm, z_size=0.1mm)
  C2_16.sweep_around_axis(axis=Z, angle=90deg, segments=15)
  C2_16.move(25.4mm, -5.1mm, 2.85mm)
  ToolC2_16_1 = box(corner=(46.85mm, -5.1mm, 2.8mm), size=(-7.03333mm, 10.2mm, 0.1mm))
  ToolC2_16_2 = rectangle(corner=(21.45mm, 0mm, -0.05mm), z_size=0.1mm, x_size=-7.03333mm)
  ToolC2_16_2.sweep_around_axis(axis=Z, angle=90deg, segments=15)
  ToolC2_16_2.move(25.4mm, 5.1mm, 2.85mm)
  ToolC2_16_3 = box(corner=(25.4mm, 26.55mm, 2.8mm), size=(-50.8mm, -7.03333mm, 0.1mm))
  ToolC2_16_4 = rectangle(corner=(0mm, 21.45mm, -0.05mm), y_size=-7.03333mm, z_size=0.1mm)
  ToolC2_16_4.sweep_around_axis(axis=Z, angle=90deg, segments=15)
  ToolC2_16_4.move(-25.4mm, 5.1mm, 2.85mm)
  ToolC2_16_5 = box(corner=(-46.85mm, 5.1mm, 2.8mm), size=(7.03333mm, -10.2mm, 0.1mm))
  ToolC2_16_6 = rectangle(corner=(-21.45mm, 0mm, -0.05mm), z_size=0.1mm, x_size=7.03333mm)
  ToolC2_16_6.sweep_around_axis(axis=Z, angle=90deg, segments=15)
  ToolC2_16_6.move(-25.4mm, -5.1mm, 2.85mm)
  ToolC2_16_7 = box(corner=(-25.4mm, -26.55mm, 2.8mm), size=(50.8mm, 7.03333mm, 0.1mm))
  C2_16.unite(ToolC2_16_1..ToolC2_16_7)
  C3_3 [CondMat3_1, surface CondMat3_1_surface] = rectangle(corner=(0mm, -7.28333mm, -0.05mm), y_size=7.03333mm, z_size=0.1mm)
  C3_3.sweep_around_axis(axis=Z, angle=90deg, segments=15)
  C3_3.move(25.4mm, -5.1mm, 2.65mm)
  ToolC3_3_1 = box(corner=(32.68333mm, -5.1mm, 2.6mm), size=(-7.03333mm, 10.2mm, 0.1mm))
  ToolC3_3_2 = rectangle(corner=(7.28333mm, 0mm, -0.05mm), z_size=0.1mm, x_size=-7.03333mm)
  ToolC3_3_2.sweep_around_axis(axis=Z, angle=90deg, segments=15)
  ToolC3_3_2.move(25.4mm, 5.1mm, 2.65mm)
  ToolC3_3_3 = box(corner=(25.4mm, 12.38333mm, 2.6mm), size=(-50.8mm, -7.03333mm, 0.1mm))
  ToolC3_3_4 = rectangle(corner=(0mm, 7.28333mm, -0.05mm), y_size=-7.03333mm, z_size=0.1mm)
  ToolC3_3_4.sweep_around_axis(axis=Z, angle=90deg, segments=15)
  ToolC3_3_4.move(-25.4mm, 5.1mm, 2.65mm)
  ToolC3_3_5 = box(corner=(-32.68333mm, 5.1mm, 2.6mm), size=(7.03333mm, -10.2mm, 0.1mm))
  ToolC3_3_6 = rectangle(corner=(-7.28333mm, 0mm, -0.05mm), z_size=0.1mm, x_size=7.03333mm)
  ToolC3_3_6.sweep_around_axis(axis=Z, angle=90deg, segments=15)
  ToolC3_3_6.move(-25.4mm, -5.1mm, 2.65mm)
  ToolC3_3_7 = box(corner=(-25.4mm, -12.38333mm, 2.6mm), size=(50.8mm, 7.03333mm, 0.1mm))
  C3_3.unite(ToolC3_3_1..ToolC3_3_7)
  C3_2 [CondMat3_1, surface CondMat3_1_surface] = rectangle(corner=(0mm, -14.36666mm, -0.05mm), y_size=7.03333mm, z_size=0.1mm)
  C3_2.sweep_around_axis(axis=Z, angle=90deg, segments=15)
  C3_2.move(25.4mm, -5.1mm, 2.65mm)
  ToolC3_2_1 = box(corner=(39.76666mm, -5.1mm, 2.6mm), size=(-7.03333mm, 10.2mm, 0.1mm))
  ToolC3_2_2 = rectangle(corner=(14.36666mm, 0mm, -0.05mm), z_size=0.1mm, x_size=-7.03333mm)
  ToolC3_2_2.sweep_around_axis(axis=Z, angle=90deg, segments=15)
  ToolC3_2_2.move(25.4mm, 5.1mm, 2.65mm)
  ToolC3_2_3 = box(corner=(25.4mm, 19.46666mm, 2.6mm), size=(-50.8mm, -7.03333mm, 0.1mm))
  ToolC3_2_4 = rectangle(corner=(0mm, 14.36666mm, -0.05mm), y_size=-7.03333mm, z_size=0.1mm)
  ToolC3_2_4.sweep_around_axis(axis=Z, angle=90deg, segments=15)
  ToolC3_2_4.move(-25.4mm, 5.1mm, 2.65mm)
  ToolC3_2_5 = box(corner=(-39.76666mm, 5.1mm, 2.6mm), size=(7.03333mm, -10.2mm, 0.1mm))
  ToolC3_2_6 = rectangle(corner=(-14.36666mm, 0mm, -0.05mm), z_size=0.1mm, x_size=7.03333mm)
  ToolC3_2_6.sweep_around_axis(axis=Z, angle=90deg, segments=15)
  ToolC3_2_6.move(-25.4mm, -5.1mm, 2.65mm)
  ToolC3_2_7 = box(corner=(-25.4mm, -19.46666mm, 2.6mm), size=(50.8mm, 7.03333mm, 0.1mm))
  C3_2.unite(ToolC3_2_1..ToolC3_2_7)
  C3_1 [CondMat3_1, surface CondMat3_1_surface] = rectangle(corner=(0mm, -21.45mm, -0.05mm), y_size=7.03333mm, z_size=0.1mm)
  C3_1.sweep_around_axis(axis=Z, angle=90deg, segments=15)
  C3_1.move(25.4mm, -5.1mm, 2.65mm)
  ToolC3_1_1 = box(corner=(46.85mm, -5.1mm, 2.6mm), size=(-7.03333mm, 10.2mm, 0.1mm))
  ToolC3_1_2 = rectangle(corner=(21.45mm, 0mm, -0.05mm), z_size=0.1mm, x_size=-7.03333mm)
  ToolC3_1_2.sweep_around_axis(axis=Z, angle=90deg, segments=15)
  ToolC3_1_2.move(25.4mm, 5.1mm, 2.65mm)
  ToolC3_1_3 = box(corner=(25.4mm, 26.55mm, 2.6mm), size=(-50.8mm, -7.03333mm, 0.1mm))
  ToolC3_1_4 = rectangle(corner=(0mm, 21.45mm, -0.05mm), y_size=-7.03333mm, z_size=0.1mm)
  ToolC3_1_4.sweep_around_axis(axis=Z, angle=90deg, segments=15)
  ToolC3_1_4.move(-25.4mm, 5.1mm, 2.65mm)
  ToolC3_1_5 = box(corner=(-46.85mm, 5.1mm, 2.6mm), size=(7.03333mm, -10.2mm, 0.1mm))
  ToolC3_1_6 = rectangle(corner=(-21.45mm, 0mm, -0.05mm), z_size=0.1mm, x_size=7.03333mm)
  ToolC3_1_6.sweep_around_axis(axis=Z, angle=90deg, segments=15)
  ToolC3_1_6.move(-25.4mm, -5.1mm, 2.65mm)
  ToolC3_1_7 = box(corner=(-25.4mm, -26.55mm, 2.6mm), size=(50.8mm, 7.03333mm, 0.1mm))
  C3_1.unite(ToolC3_1_1..ToolC3_1_7)
  C3_6 [CondMat3_2, surface CondMat3_2_surface] = rectangle(corner=(0mm, -7.28333mm, -0.05mm), y_size=7.03333mm, z_size=0.1mm)
  C3_6.sweep_around_axis(axis=Z, angle=90deg, segments=15)
  C3_6.move(25.4mm, -5.1mm, 2.45mm)
  ToolC3_6_1 = box(corner=(32.68333mm, -5.1mm, 2.4mm), size=(-7.03333mm, 10.2mm, 0.1mm))
  ToolC3_6_2 = rectangle(corner=(7.28333mm, 0mm, -0.05mm), z_size=0.1mm, x_size=-7.03333mm)
  ToolC3_6_2.sweep_around_axis(axis=Z, angle=90deg, segments=15)
  ToolC3_6_2.move(25.4mm, 5.1mm, 2.45mm)
  ToolC3_6_3 = box(corner=(25.4mm, 12.38333mm, 2.4mm), size=(-50.8mm, -7.03333mm, 0.1mm))
  ToolC3_6_4 = rectangle(corner=(0mm, 7.28333mm, -0.05mm), y_size=-7.03333mm, z_size=0.1mm)
  ToolC3_6_4.sweep_around_axis(axis=Z, angle=90deg, segments=15)
  ToolC3_6_4.move(-25.4mm, 5.1mm, 2.45mm)
  ToolC3_6_5 = box(corner=(-32.68333mm, 5.1mm, 2.4mm), size=(7.03333mm, -10.2mm, 0.1mm))
  ToolC3_6_6 = rectangle(corner=(-7.28333mm, 0mm, -0.05mm), z_size=0.1mm, x_size=7.03333mm)
  ToolC3_6_6.sweep_around_axis(axis=Z, angle=90deg, segments=15)
  ToolC3_6_6.move(-25.4mm, -5.1mm, 2.45mm)
  ToolC3_6_7 = box(corner=(-25.4mm, -12.38333mm, 2.4mm), size=(50.8mm, 7.03333mm, 0.1mm))
  C3_6.unite(ToolC3_6_1..ToolC3_6_7)
  C3_5 [CondMat3_2, surface CondMat3_2_surface] = rectangle(corner=(0mm, -14.36666mm, -0.05mm), y_size=7.03333mm, z_size=0.1mm)
  C3_5.sweep_around_axis(axis=Z, angle=90deg, segments=15)
  C3_5.move(25.4mm, -5.1mm, 2.45mm)
  ToolC3_5_1 = box(corner=(39.76666mm, -5.1mm, 2.4mm), size=(-7.03333mm, 10.2mm, 0.1mm))
  ToolC3_5_2 = rectangle(corner=(14.36666mm, 0mm, -0.05mm), z_size=0.1mm, x_size=-7.03333mm)
  ToolC3_5_2.sweep_around_axis(axis=Z, angle=90deg, segments=15)
  ToolC3_5_2.move(25.4mm, 5.1mm, 2.45mm)
  ToolC3_5_3 = box(corner=(25.4mm, 19.46666mm, 2.4mm), size=(-50.8mm, -7.03333mm, 0.1mm))
  ToolC3_5_4 = rectangle(corner=(0mm, 14.36666mm, -0.05mm), y_size=-7.03333mm, z_size=0.1mm)
  ToolC3_5_4.sweep_around_axis(axis=Z, angle=90deg, segments=15)
  ToolC3_5_4.move(-25.4mm, 5.1mm, 2.45mm)
  ToolC3_5_5 = box(corner=(-39.76666mm, 5.1mm, 2.4mm), size=(7.03333mm, -10.2mm, 0.1mm))
  ToolC3_5_6 = rectangle(corner=(-14.36666mm, 0mm, -0.05mm), z_size=0.1mm, x_size=7.03333mm)
  ToolC3_5_6.sweep_around_axis(axis=Z, angle=90deg, segments=15)
  ToolC3_5_6.move(-25.4mm, -5.1mm, 2.45mm)
  ToolC3_5_7 = box(corner=(-25.4mm, -19.46666mm, 2.4mm), size=(50.8mm, 7.03333mm, 0.1mm))
  C3_5.unite(ToolC3_5_1..ToolC3_5_7)
  C3_4 [CondMat3_2, surface CondMat3_2_surface] = rectangle(corner=(0mm, -21.45mm, -0.05mm), y_size=7.03333mm, z_size=0.1mm)
  C3_4.sweep_around_axis(axis=Z, angle=90deg, segments=15)
  C3_4.move(25.4mm, -5.1mm, 2.45mm)
  ToolC3_4_1 = box(corner=(46.85mm, -5.1mm, 2.4mm), size=(-7.03333mm, 10.2mm, 0.1mm))
  ToolC3_4_2 = rectangle(corner=(21.45mm, 0mm, -0.05mm), z_size=0.1mm, x_size=-7.03333mm)
  ToolC3_4_2.sweep_around_axis(axis=Z, angle=90deg, segments=15)
  ToolC3_4_2.move(25.4mm, 5.1mm, 2.45mm)
  ToolC3_4_3 = box(corner=(25.4mm, 26.55mm, 2.4mm), size=(-50.8mm, -7.03333mm, 0.1mm))
  ToolC3_4_4 = rectangle(corner=(0mm, 21.45mm, -0.05mm), y_size=-7.03333mm, z_size=0.1mm)
  ToolC3_4_4.sweep_around_axis(axis=Z, angle=90deg, segments=15)
  ToolC3_4_4.move(-25.4mm, 5.1mm, 2.45mm)
  ToolC3_4_5 = box(corner=(-46.85mm, 5.1mm, 2.4mm), size=(7.03333mm, -10.2mm, 0.1mm))
  ToolC3_4_6 = rectangle(corner=(-21.45mm, 0mm, -0.05mm), z_size=0.1mm, x_size=7.03333mm)
  ToolC3_4_6.sweep_around_axis(axis=Z, angle=90deg, segments=15)
  ToolC3_4_6.move(-25.4mm, -5.1mm, 2.45mm)
  ToolC3_4_7 = box(corner=(-25.4mm, -26.55mm, 2.4mm), size=(50.8mm, 7.03333mm, 0.1mm))
  C3_4.unite(ToolC3_4_1..ToolC3_4_7)
  C3_9 [CondMat3_3, surface CondMat3_3_surface] = rectangle(corner=(0mm, -7.28333mm, -0.05mm), y_size=7.03333mm, z_size=0.1mm)
  C3_9.sweep_around_axis(axis=Z, angle=90deg, segments=15)
  C3_9.move(25.4mm, -5.1mm, 2.25mm)
  ToolC3_9_1 = box(corner=(32.68333mm, -5.1mm, 2.2mm), size=(-7.03333mm, 10.2mm, 0.1mm))
  ToolC3_9_2 = rectangle(corner=(7.28333mm, 0mm, -0.05mm), z_size=0.1mm, x_size=-7.03333mm)
  ToolC3_9_2.sweep_around_axis(axis=Z, angle=90deg, segments=15)
  ToolC3_9_2.move(25.4mm, 5.1mm, 2.25mm)
  ToolC3_9_3 = box(corner=(25.4mm, 12.38333mm, 2.2mm), size=(-50.8mm, -7.03333mm, 0.1mm))
  ToolC3_9_4 = rectangle(corner=(0mm, 7.28333mm, -0.05mm), y_size=-7.03333mm, z_size=0.1mm)
  ToolC3_9_4.sweep_around_axis(axis=Z, angle=90deg, segments=15)
  ToolC3_9_4.move(-25.4mm, 5.1mm, 2.25mm)
  ToolC3_9_5 = box(corner=(-32.68333mm, 5.1mm, 2.2mm), size=(7.03333mm, -10.2mm, 0.1mm))
  ToolC3_9_6 = rectangle(corner=(-7.28333mm, 0mm, -0.05mm), z_size=0.1mm, x_size=7.03333mm)
  ToolC3_9_6.sweep_around_axis(axis=Z, angle=90deg, segments=15)
  ToolC3_9_6.move(-25.4mm, -5.1mm, 2.25mm)
  ToolC3_9_7 = box(corner=(-25.4mm, -12.38333mm, 2.2mm), size=(50.8mm, 7.03333mm, 0.1mm))
  C3_9.unite(ToolC3_9_1..ToolC3_9_7)
  C3_8 [CondMat3_3, surface CondMat3_3_surface] = rectangle(corner=(0mm, -14.36666mm, -0.05mm), y_size=7.03333mm, z_size=0.1mm)
  C3_8.sweep_around_axis(axis=Z, angle=90deg, segments=15)
  C3_8.move(25.4mm, -5.1mm, 2.25mm)
  ToolC3_8_1 = box(corner=(39.76666mm, -5.1mm, 2.2mm), size=(-7.03333mm, 10.2mm, 0.1mm))
  ToolC3_8_2 = rectangle(corner=(14.36666mm, 0mm, -0.05mm), z_size=0.1mm, x_size=-7.03333mm)
  ToolC3_8_2.sweep_around_axis(axis=Z, angle=90deg, segments=15)
  ToolC3_8_2.move(25.4mm, 5.1mm, 2.25mm)
  ToolC3_8_3 = box(corner=(25.4mm, 19.46666mm, 2.2mm), size=(-50.8mm, -7.03333mm, 0.1mm))
  ToolC3_8_4 = rectangle(corner=(0mm, 14.36666mm, -0.05mm), y_size=-7.03333mm, z_size=0.1mm)
  ToolC3_8_4.sweep_around_axis(axis=Z, angle=90deg, segments=15)
  ToolC3_8_4.move(-25.4mm, 5.1mm, 2.25mm)
  ToolC3_8_5 = box(corner=(-39.76666mm, 5.1mm, 2.2mm), size=(7.03333mm, -10.2mm, 0.1mm))
  ToolC3_8_6 = rectangle(corner=(-14.36666mm, 0mm, -0.05mm), z_size=0.1mm, x_size=7.03333mm)
  ToolC3_8_6.sweep_around_axis(axis=Z, angle=90deg, segments=15)
  ToolC3_8_6.move(-25.4mm, -5.1mm, 2.25mm)
  ToolC3_8_7 = box(corner=(-25.4mm, -19.46666mm, 2.2mm), size=(50.8mm, 7.03333mm, 0.1mm))
  C3_8.unite(ToolC3_8_1..ToolC3_8_7)
  C3_7 [CondMat3_3, surface CondMat3_3_surface] = rectangle(corner=(0mm, -21.45mm, -0.05mm), y_size=7.03333mm, z_size=0.1mm)
  C3_7.sweep_around_axis(axis=Z, angle=90deg, segments=15)
  C3_7.move(25.4mm, -5.1mm, 2.25mm)
  ToolC3_7_1 = box(corner=(46.85mm, -5.1mm, 2.2mm), size=(-7.03333mm, 10.2mm, 0.1mm))
  ToolC3_7_2 = rectangle(corner=(21.45mm, 0mm, -0.05mm), z_size=0.1mm, x_size=-7.03333mm)
  ToolC3_7_2.sweep_around_axis(axis=Z, angle=90deg, segments=15)
  ToolC3_7_2.move(25.4mm, 5.1mm, 2.25mm)
  ToolC3_7_3 = box(corner=(25.4mm, 26.55mm, 2.2mm), size=(-50.8mm, -7.03333mm, 0.1mm))
  ToolC3_7_4 = rectangle(corner=(0mm, 21.45mm, -0.05mm), y_size=-7.03333mm, z_size=0.1mm)
  ToolC3_7_4.sweep_around_axis(axis=Z, angle=90deg, segments=15)
  ToolC3_7_4.move(-25.4mm, 5.1mm, 2.25mm)
  ToolC3_7_5 = box(corner=(-46.85mm, 5.1mm, 2.2mm), size=(7.03333mm, -10.2mm, 0.1mm))
  ToolC3_7_6 = rectangle(corner=(-21.45mm, 0mm, -0.05mm), z_size=0.1mm, x_size=7.03333mm)
  ToolC3_7_6.sweep_around_axis(axis=Z, angle=90deg, segments=15)
  ToolC3_7_6.move(-25.4mm, -5.1mm, 2.25mm)
  ToolC3_7_7 = box(corner=(-25.4mm, -26.55mm, 2.2mm), size=(50.8mm, 7.03333mm, 0.1mm))
  C3_7.unite(ToolC3_7_1..ToolC3_7_7)
  C3_12 [CondMat3_4, surface CondMat3_4_surface] = rectangle(corner=(0mm, -7.28333mm, -0.05mm), y_size=7.03333mm, z_size=0.1mm)
  C3_12.sweep_around_axis(axis=Z, angle=90deg, segments=15)
  C3_12.move(25.4mm, -5.1mm, 2.05mm)
  ToolC3_12_1 = box(corner=(32.68333mm, -5.1mm, 2mm), size=(-7.03333mm, 10.2mm, 0.1mm))
  ToolC3_12_2 = rectangle(corner=(7.28333mm, 0mm, -0.05mm), z_size=0.1mm, x_size=-7.03333mm)
  ToolC3_12_2.sweep_around_axis(axis=Z, angle=90deg, segments=15)
  ToolC3_12_2.move(25.4mm, 5.1mm, 2.05mm)
  ToolC3_12_3 = box(corner=(25.4mm, 12.38333mm, 2mm), size=(-50.8mm, -7.03333mm, 0.1mm))
  ToolC3_12_4 = rectangle(corner=(0mm, 7.28333mm, -0.05mm), y_size=-7.03333mm, z_size=0.1mm)
  ToolC3_12_4.sweep_around_axis(axis=Z, angle=90deg, segments=15)
  ToolC3_12_4.move(-25.4mm, 5.1mm, 2.05mm)
  ToolC3_12_5 = box(corner=(-32.68333mm, 5.1mm, 2mm), size=(7.03333mm, -10.2mm, 0.1mm))
  ToolC3_12_6 = rectangle(corner=(-7.28333mm, 0mm, -0.05mm), z_size=0.1mm, x_size=7.03333mm)
  ToolC3_12_6.sweep_around_axis(axis=Z, angle=90deg, segments=15)
  ToolC3_12_6.move(-25.4mm, -5.1mm, 2.05mm)
  ToolC3_12_7 = box(corner=(-25.4mm, -12.38333mm, 2mm), size=(50.8mm, 7.03333mm, 0.1mm))
  C3_12.unite(ToolC3_12_1..ToolC3_12_7)
  C3_11 [CondMat3_4, surface CondMat3_4_surface] = rectangle(corner=(0mm, -14.36666mm, -0.05mm), y_size=7.03333mm, z_size=0.1mm)
  C3_11.sweep_around_axis(axis=Z, angle=90deg, segments=15)
  C3_11.move(25.4mm, -5.1mm, 2.05mm)
  ToolC3_11_1 = box(corner=(39.76666mm, -5.1mm, 2mm), size=(-7.03333mm, 10.2mm, 0.1mm))
  ToolC3_11_2 = rectangle(corner=(14.36666mm, 0mm, -0.05mm), z_size=0.1mm, x_size=-7.03333mm)
  ToolC3_11_2.sweep_around_axis(axis=Z, angle=90deg, segments=15)
  ToolC3_11_2.move(25.4mm, 5.1mm, 2.05mm)
  ToolC3_11_3 = box(corner=(25.4mm, 19.46666mm, 2mm), size=(-50.8mm, -7.03333mm, 0.1mm))
  ToolC3_11_4 = rectangle(corner=(0mm, 14.36666mm, -0.05mm), y_size=-7.03333mm, z_size=0.1mm)
  ToolC3_11_4.sweep_around_axis(axis=Z, angle=90deg, segments=15)
  ToolC3_11_4.move(-25.4mm, 5.1mm, 2.05mm)
  ToolC3_11_5 = box(corner=(-39.76666mm, 5.1mm, 2mm), size=(7.03333mm, -10.2mm, 0.1mm))
  ToolC3_11_6 = rectangle(corner=(-14.36666mm, 0mm, -0.05mm), z_size=0.1mm, x_size=7.03333mm)
  ToolC3_11_6.sweep_around_axis(axis=Z, angle=90deg, segments=15)
  ToolC3_11_6.move(-25.4mm, -5.1mm, 2.05mm)
  ToolC3_11_7 = box(corner=(-25.4mm, -19.46666mm, 2mm), size=(50.8mm, 7.03333mm, 0.1mm))
  C3_11.unite(ToolC3_11_1..ToolC3_11_7)
  C3_10 [CondMat3_4, surface CondMat3_4_surface] = rectangle(corner=(0mm, -21.45mm, -0.05mm), y_size=7.03333mm, z_size=0.1mm)
  C3_10.sweep_around_axis(axis=Z, angle=90deg, segments=15)
  C3_10.move(25.4mm, -5.1mm, 2.05mm)
  ToolC3_10_1 = box(corner=(46.85mm, -5.1mm, 2mm), size=(-7.03333mm, 10.2mm, 0.1mm))
  ToolC3_10_2 = rectangle(corner=(21.45mm, 0mm, -0.05mm), z_size=0.1mm, x_size=-7.03333mm)
  ToolC3_10_2.sweep_around_axis(axis=Z, angle=90deg, segments=15)
  ToolC3_10_2.move(25.4mm, 5.1mm, 2.05mm)
  ToolC3_10_3 = box(corner=(25.4mm, 26.55mm, 2mm), size=(-50.8mm, -7.03333mm, 0.1mm))
  ToolC3_10_4 = rectangle(corner=(0mm, 21.45mm, -0.05mm), y_size=-7.03333mm, z_size=0.1mm)
  ToolC3_10_4.sweep_around_axis(axis=Z, angle=90deg, segments=15)
  ToolC3_10_4.move(-25.4mm, 5.1mm, 2.05mm)
  ToolC3_10_5 = box(corner=(-46.85mm, 5.1mm, 2mm), size=(7.03333mm, -10.2mm, 0.1mm))
  ToolC3_10_6 = rectangle(corner=(-21.45mm, 0mm, -0.05mm), z_size=0.1mm, x_size=7.03333mm)
  ToolC3_10_6.sweep_around_axis(axis=Z, angle=90deg, segments=15)
  ToolC3_10_6.move(-25.4mm, -5.1mm, 2.05mm)
  ToolC3_10_7 = box(corner=(-25.4mm, -26.55mm, 2mm), size=(50.8mm, 7.03333mm, 0.1mm))
  C3_10.unite(ToolC3_10_1..ToolC3_10_7)
  C3_15 [CondMat3_5, surface CondMat3_5_surface] = rectangle(corner=(0mm, -7.28333mm, -0.05mm), y_size=7.03333mm, z_size=0.1mm)
  C3_15.sweep_around_axis(axis=Z, angle=90deg, segments=15)
  C3_15.move(25.4mm, -5.1mm, 1.85mm)
  ToolC3_15_1 = box(corner=(32.68333mm, -5.1mm, 1.8mm), size=(-7.03333mm, 10.2mm, 0.1mm))
  ToolC3_15_2 = rectangle(corner=(7.28333mm, 0mm, -0.05mm), z_size=0.1mm, x_size=-7.03333mm)
  ToolC3_15_2.sweep_around_axis(axis=Z, angle=90deg, segments=15)
  ToolC3_15_2.move(25.4mm, 5.1mm, 1.85mm)
  ToolC3_15_3 = box(corner=(25.4mm, 12.38333mm, 1.8mm), size=(-50.8mm, -7.03333mm, 0.1mm))
  ToolC3_15_4 = rectangle(corner=(0mm, 7.28333mm, -0.05mm), y_size=-7.03333mm, z_size=0.1mm)
  ToolC3_15_4.sweep_around_axis(axis=Z, angle=90deg, segments=15)
  ToolC3_15_4.move(-25.4mm, 5.1mm, 1.85mm)
  ToolC3_15_5 = box(corner=(-32.68333mm, 5.1mm, 1.8mm), size=(7.03333mm, -10.2mm, 0.1mm))
  ToolC3_15_6 = rectangle(corner=(-7.28333mm, 0mm, -0.05mm), z_size=0.1mm, x_size=7.03333mm)
  ToolC3_15_6.sweep_around_axis(axis=Z, angle=90deg, segments=15)
  ToolC3_15_6.move(-25.4mm, -5.1mm, 1.85mm)
  ToolC3_15_7 = box(corner=(-25.4mm, -12.38333mm, 1.8mm), size=(50.8mm, 7.03333mm, 0.1mm))
  C3_15.unite(ToolC3_15_1..ToolC3_15_7)
  C3_14 [CondMat3_5, surface CondMat3_5_surface] = rectangle(corner=(0mm, -14.36666mm, -0.05mm), y_size=7.03333mm, z_size=0.1mm)
  C3_14.sweep_around_axis(axis=Z, angle=90deg, segments=15)
  C3_14.move(25.4mm, -5.1mm, 1.85mm)
  ToolC3_14_1 = box(corner=(39.76666mm, -5.1mm, 1.8mm), size=(-7.03333mm, 10.2mm, 0.1mm))
  ToolC3_14_2 = rectangle(corner=(14.36666mm, 0mm, -0.05mm), z_size=0.1mm, x_size=-7.03333mm)
  ToolC3_14_2.sweep_around_axis(axis=Z, angle=90deg, segments=15)
  ToolC3_14_2.move(25.4mm, 5.1mm, 1.85mm)
  ToolC3_14_3 = box(corner=(25.4mm, 19.46666mm, 1.8mm), size=(-50.8mm, -7.03333mm, 0.1mm))
  ToolC3_14_4 = rectangle(corner=(0mm, 14.36666mm, -0.05mm), y_size=-7.03333mm, z_size=0.1mm)
  ToolC3_14_4.sweep_around_axis(axis=Z, angle=90deg, segments=15)
  ToolC3_14_4.move(-25.4mm, 5.1mm, 1.85mm)
  ToolC3_14_5 = box(corner=(-39.76666mm, 5.1mm, 1.8mm), size=(7.03333mm, -10.2mm, 0.1mm))
  ToolC3_14_6 = rectangle(corner=(-14.36666mm, 0mm, -0.05mm), z_size=0.1mm, x_size=7.03333mm)
  ToolC3_14_6.sweep_around_axis(axis=Z, angle=90deg, segments=15)
  ToolC3_14_6.move(-25.4mm, -5.1mm, 1.85mm)
  ToolC3_14_7 = box(corner=(-25.4mm, -19.46666mm, 1.8mm), size=(50.8mm, 7.03333mm, 0.1mm))
  C3_14.unite(ToolC3_14_1..ToolC3_14_7)
  C3_13 [CondMat3_5, surface CondMat3_5_surface] = rectangle(corner=(0mm, -21.45mm, -0.05mm), y_size=7.03333mm, z_size=0.1mm)
  C3_13.sweep_around_axis(axis=Z, angle=90deg, segments=15)
  C3_13.move(25.4mm, -5.1mm, 1.85mm)
  ToolC3_13_1 = box(corner=(46.85mm, -5.1mm, 1.8mm), size=(-7.03333mm, 10.2mm, 0.1mm))
  ToolC3_13_2 = rectangle(corner=(21.45mm, 0mm, -0.05mm), z_size=0.1mm, x_size=-7.03333mm)
  ToolC3_13_2.sweep_around_axis(axis=Z, angle=90deg, segments=15)
  ToolC3_13_2.move(25.4mm, 5.1mm, 1.85mm)
  ToolC3_13_3 = box(corner=(25.4mm, 26.55mm, 1.8mm), size=(-50.8mm, -7.03333mm, 0.1mm))
  ToolC3_13_4 = rectangle(corner=(0mm, 21.45mm, -0.05mm), y_size=-7.03333mm, z_size=0.1mm)
  ToolC3_13_4.sweep_around_axis(axis=Z, angle=90deg, segments=15)
  ToolC3_13_4.move(-25.4mm, 5.1mm, 1.85mm)
  ToolC3_13_5 = box(corner=(-46.85mm, 5.1mm, 1.8mm), size=(7.03333mm, -10.2mm, 0.1mm))
  ToolC3_13_6 = rectangle(corner=(-21.45mm, 0mm, -0.05mm), z_size=0.1mm, x_size=7.03333mm)
  ToolC3_13_6.sweep_around_axis(axis=Z, angle=90deg, segments=15)
  ToolC3_13_6.move(-25.4mm, -5.1mm, 1.85mm)
  ToolC3_13_7 = box(corner=(-25.4mm, -26.55mm, 1.8mm), size=(50.8mm, 7.03333mm, 0.1mm))
  C3_13.unite(ToolC3_13_1..ToolC3_13_7)
  C3_18 [CondMat3_6, surface CondMat3_6_surface] = rectangle(corner=(0mm, -7.28333mm, -0.05mm), y_size=7.03333mm, z_size=0.1mm)
  C3_18.sweep_around_axis(axis=Z, angle=90deg, segments=15)
  C3_18.move(25.4mm, -5.1mm, 1.65mm)
  ToolC3_18_1 = box(corner=(32.68333mm, -5.1mm, 1.6mm), size=(-7.03333mm, 10.2mm, 0.1mm))
  ToolC3_18_2 = rectangle(corner=(7.28333mm, 0mm, -0.05mm), z_size=0.1mm, x_size=-7.03333mm)
  ToolC3_18_2.sweep_around_axis(axis=Z, angle=90deg, segments=15)
  ToolC3_18_2.move(25.4mm, 5.1mm, 1.65mm)
  ToolC3_18_3 = box(corner=(25.4mm, 12.38333mm, 1.6mm), size=(-50.8mm, -7.03333mm, 0.1mm))
  ToolC3_18_4 = rectangle(corner=(0mm, 7.28333mm, -0.05mm), y_size=-7.03333mm, z_size=0.1mm)
  ToolC3_18_4.sweep_around_axis(axis=Z, angle=90deg, segments=15)
  ToolC3_18_4.move(-25.4mm, 5.1mm, 1.65mm)
  ToolC3_18_5 = box(corner=(-32.68333mm, 5.1mm, 1.6mm), size=(7.03333mm, -10.2mm, 0.1mm))
  ToolC3_18_6 = rectangle(corner=(-7.28333mm, 0mm, -0.05mm), z_size=0.1mm, x_size=7.03333mm)
  ToolC3_18_6.sweep_around_axis(axis=Z, angle=90deg, segments=15)
  ToolC3_18_6.move(-25.4mm, -5.1mm, 1.65mm)
  ToolC3_18_7 = box(corner=(-25.4mm, -12.38333mm, 1.6mm), size=(50.8mm, 7.03333mm, 0.1mm))
  C3_18.unite(ToolC3_18_1..ToolC3_18_7)
  C3_17 [CondMat3_6, surface CondMat3_6_surface] = rectangle(corner=(0mm, -14.36666mm, -0.05mm), y_size=7.03333mm, z_size=0.1mm)
  C3_17.sweep_around_axis(axis=Z, angle=90deg, segments=15)
  C3_17.move(25.4mm, -5.1mm, 1.65mm)
  ToolC3_17_1 = box(corner=(39.76666mm, -5.1mm, 1.6mm), size=(-7.03333mm, 10.2mm, 0.1mm))
  ToolC3_17_2 = rectangle(corner=(14.36666mm, 0mm, -0.05mm), z_size=0.1mm, x_size=-7.03333mm)
  ToolC3_17_2.sweep_around_axis(axis=Z, angle=90deg, segments=15)
  ToolC3_17_2.move(25.4mm, 5.1mm, 1.65mm)
  ToolC3_17_3 = box(corner=(25.4mm, 19.46666mm, 1.6mm), size=(-50.8mm, -7.03333mm, 0.1mm))
  ToolC3_17_4 = rectangle(corner=(0mm, 14.36666mm, -0.05mm), y_size=-7.03333mm, z_size=0.1mm)
  ToolC3_17_4.sweep_around_axis(axis=Z, angle=90deg, segments=15)
  ToolC3_17_4.move(-25.4mm, 5.1mm, 1.65mm)
  ToolC3_17_5 = box(corner=(-39.76666mm, 5.1mm, 1.6mm), size=(7.03333mm, -10.2mm, 0.1mm))
  ToolC3_17_6 = rectangle(corner=(-14.36666mm, 0mm, -0.05mm), z_size=0.1mm, x_size=7.03333mm)
  ToolC3_17_6.sweep_around_axis(axis=Z, angle=90deg, segments=15)
  ToolC3_17_6.move(-25.4mm, -5.1mm, 1.65mm)
  ToolC3_17_7 = box(corner=(-25.4mm, -19.46666mm, 1.6mm), size=(50.8mm, 7.03333mm, 0.1mm))
  C3_17.unite(ToolC3_17_1..ToolC3_17_7)
  C3_16 [CondMat3_6, surface CondMat3_6_surface] = rectangle(corner=(0mm, -21.45mm, -0.05mm), y_size=7.03333mm, z_size=0.1mm)
  C3_16.sweep_around_axis(axis=Z, angle=90deg, segments=15)
  C3_16.move(25.4mm, -5.1mm, 1.65mm)
  ToolC3_16_1 = box(corner=(46.85mm, -5.1mm, 1.6mm), size=(-7.03333mm, 10.2mm, 0.1mm))
  ToolC3_16_2 = rectangle(corner=(21.45mm, 0mm, -0.05mm), z_size=0.1mm, x_size=-7.03333mm)
  ToolC3_16_2.sweep_around_axis(axis=Z, angle=90deg, segments=15)
  ToolC3_16_2.move(25.4mm, 5.1mm, 1.65mm)
  ToolC3_16_3 = box(corner=(25.4mm, 26.55mm, 1.6mm), size=(-50.8mm, -7.03333mm, 0.1mm))
  ToolC3_16_4 = rectangle(corner=(0mm, 21.45mm, -0.05mm), y_size=-7.03333mm, z_size=0.1mm)
  ToolC3_16_4.sweep_around_axis(axis=Z, angle=90deg, segments=15)
  ToolC3_16_4.move(-25.4mm, 5.1mm, 1.65mm)
  ToolC3_16_5 = box(corner=(-46.85mm, 5.1mm, 1.6mm), size=(7.03333mm, -10.2mm, 0.1mm))
  ToolC3_16_6 = rectangle(corner=(-21.45mm, 0mm, -0.05mm), z_size=0.1mm, x_size=7.03333mm)
  ToolC3_16_6.sweep_around_axis(axis=Z, angle=90deg, segments=15)
  ToolC3_16_6.move(-25.4mm, -5.1mm, 1.65mm)
  ToolC3_16_7 = box(corner=(-25.4mm, -26.55mm, 1.6mm), size=(50.8mm, 7.03333mm, 0.1mm))
  C3_16.unite(ToolC3_16_1..ToolC3_16_7)
  C4_3 [CondMat4_1, surface CondMat4_1_surface] = rectangle(corner=(0mm, -7.28333mm, -0.05mm), y_size=7.03333mm, z_size=0.1mm)
  C4_3.sweep_around_axis(axis=Z, angle=90deg, segments=15)
  C4_3.move(25.4mm, -5.1mm, 1.45mm)
  ToolC4_3_1 = box(corner=(32.68333mm, -5.1mm, 1.4mm), size=(-7.03333mm, 10.2mm, 0.1mm))
  ToolC4_3_2 = rectangle(corner=(7.28333mm, 0mm, -0.05mm), z_size=0.1mm, x_size=-7.03333mm)
  ToolC4_3_2.sweep_around_axis(axis=Z, angle=90deg, segments=15)
  ToolC4_3_2.move(25.4mm, 5.1mm, 1.45mm)
  ToolC4_3_3 = box(corner=(25.4mm, 12.38333mm, 1.4mm), size=(-50.8mm, -7.03333mm, 0.1mm))
  ToolC4_3_4 = rectangle(corner=(0mm, 7.28333mm, -0.05mm), y_size=-7.03333mm, z_size=0.1mm)
  ToolC4_3_4.sweep_around_axis(axis=Z, angle=90deg, segments=15)
  ToolC4_3_4.move(-25.4mm, 5.1mm, 1.45mm)
  ToolC4_3_5 = box(corner=(-32.68333mm, 5.1mm, 1.4mm), size=(7.03333mm, -10.2mm, 0.1mm))
  ToolC4_3_6 = rectangle(corner=(-7.28333mm, 0mm, -0.05mm), z_size=0.1mm, x_size=7.03333mm)
  ToolC4_3_6.sweep_around_axis(axis=Z, angle=90deg, segments=15)
  ToolC4_3_6.move(-25.4mm, -5.1mm, 1.45mm)
  ToolC4_3_7 = box(corner=(-25.4mm, -12.38333mm, 1.4mm), size=(50.8mm, 7.03333mm, 0.1mm))
  C4_3.unite(ToolC4_3_1..ToolC4_3_7)
  C4_2 [CondMat4_1, surface CondMat4_1_surface] = rectangle(corner=(0mm, -14.36666mm, -0.05mm), y_size=7.03333mm, z_size=0.1mm)
  C4_2.sweep_around_axis(axis=Z, angle=90deg, segments=15)
  C4_2.move(25.4mm, -5.1mm, 1.45mm)
  ToolC4_2_1 = box(corner=(39.76666mm, -5.1mm, 1.4mm), size=(-7.03333mm, 10.2mm, 0.1mm))
  ToolC4_2_2 = rectangle(corner=(14.36666mm, 0mm, -0.05mm), z_size=0.1mm, x_size=-7.03333mm)
  ToolC4_2_2.sweep_around_axis(axis=Z, angle=90deg, segments=15)
  ToolC4_2_2.move(25.4mm, 5.1mm, 1.45mm)
  ToolC4_2_3 = box(corner=(25.4mm, 19.46666mm, 1.4mm), size=(-50.8mm, -7.03333mm, 0.1mm))
  ToolC4_2_4 = rectangle(corner=(0mm, 14.36666mm, -0.05mm), y_size=-7.03333mm, z_size=0.1mm)
  ToolC4_2_4.sweep_around_axis(axis=Z, angle=90deg, segments=15)
  ToolC4_2_4.move(-25.4mm, 5.1mm, 1.45mm)
  ToolC4_2_5 = box(corner=(-39.76666mm, 5.1mm, 1.4mm), size=(7.03333mm, -10.2mm, 0.1mm))
  ToolC4_2_6 = rectangle(corner=(-14.36666mm, 0mm, -0.05mm), z_size=0.1mm, x_size=7.03333mm)
  ToolC4_2_6.sweep_around_axis(axis=Z, angle=90deg, segments=15)
  ToolC4_2_6.move(-25.4mm, -5.1mm, 1.45mm)
  ToolC4_2_7 = box(corner=(-25.4mm, -19.46666mm, 1.4mm), size=(50.8mm, 7.03333mm, 0.1mm))
  C4_2.unite(ToolC4_2_1..ToolC4_2_7)
  C4_1 [CondMat4_1, surface CondMat4_1_surface] = rectangle(corner=(0mm, -21.45mm, -0.05mm), y_size=7.03333mm, z_size=0.1mm)
  C4_1.sweep_around_axis(axis=Z, angle=90deg, segments=15)
  C4_1.move(25.4mm, -5.1mm, 1.45mm)
  ToolC4_1_1 = box(corner=(46.85mm, -5.1mm, 1.4mm), size=(-7.03333mm, 10.2mm, 0.1mm))
  ToolC4_1_2 = rectangle(corner=(21.45mm, 0mm, -0.05mm), z_size=0.1mm, x_size=-7.03333mm)
  ToolC4_1_2.sweep_around_axis(axis=Z, angle=90deg, segments=15)
  ToolC4_1_2.move(25.4mm, 5.1mm, 1.45mm)
  ToolC4_1_3 = box(corner=(25.4mm, 26.55mm, 1.4mm), size=(-50.8mm, -7.03333mm, 0.1mm))
  ToolC4_1_4 = rectangle(corner=(0mm, 21.45mm, -0.05mm), y_size=-7.03333mm, z_size=0.1mm)
  ToolC4_1_4.sweep_around_axis(axis=Z, angle=90deg, segments=15)
  ToolC4_1_4.move(-25.4mm, 5.1mm, 1.45mm)
  ToolC4_1_5 = box(corner=(-46.85mm, 5.1mm, 1.4mm), size=(7.03333mm, -10.2mm, 0.1mm))
  ToolC4_1_6 = rectangle(corner=(-21.45mm, 0mm, -0.05mm), z_size=0.1mm, x_size=7.03333mm)
  ToolC4_1_6.sweep_around_axis(axis=Z, angle=90deg, segments=15)
  ToolC4_1_6.move(-25.4mm, -5.1mm, 1.45mm)
  ToolC4_1_7 = box(corner=(-25.4mm, -26.55mm, 1.4mm), size=(50.8mm, 7.03333mm, 0.1mm))
  C4_1.unite(ToolC4_1_1..ToolC4_1_7)
  C4_6 [CondMat4_2, surface CondMat4_2_surface] = rectangle(corner=(0mm, -7.28333mm, -0.05mm), y_size=7.03333mm, z_size=0.1mm)
  C4_6.sweep_around_axis(axis=Z, angle=90deg, segments=15)
  C4_6.move(25.4mm, -5.1mm, 1.25mm)
  ToolC4_6_1 = box(corner=(32.68333mm, -5.1mm, 1.2mm), size=(-7.03333mm, 10.2mm, 0.1mm))
  ToolC4_6_2 = rectangle(corner=(7.28333mm, 0mm, -0.05mm), z_size=0.1mm, x_size=-7.03333mm)
  ToolC4_6_2.sweep_around_axis(axis=Z, angle=90deg, segments=15)
  ToolC4_6_2.move(25.4mm, 5.1mm, 1.25mm)
  ToolC4_6_3 = box(corner=(25.4mm, 12.38333mm, 1.2mm), size=(-50.8mm, -7.03333mm, 0.1mm))
  ToolC4_6_4 = rectangle(corner=(0mm, 7.28333mm, -0.05mm), y_size=-7.03333mm, z_size=0.1mm)
  ToolC4_6_4.sweep_around_axis(axis=Z, angle=90deg, segments=15)
  ToolC4_6_4.move(-25.4mm, 5.1mm, 1.25mm)
  ToolC4_6_5 = box(corner=(-32.68333mm, 5.1mm, 1.2mm), size=(7.03333mm, -10.2mm, 0.1mm))
  ToolC4_6_6 = rectangle(corner=(-7.28333mm, 0mm, -0.05mm), z_size=0.1mm, x_size=7.03333mm)
  ToolC4_6_6.sweep_around_axis(axis=Z, angle=90deg, segments=15)
  ToolC4_6_6.move(-25.4mm, -5.1mm, 1.25mm)
  ToolC4_6_7 = box(corner=(-25.4mm, -12.38333mm, 1.2mm), size=(50.8mm, 7.03333mm, 0.1mm))
  C4_6.unite(ToolC4_6_1..ToolC4_6_7)
  C4_5 [CondMat4_2, surface CondMat4_2_surface] = rectangle(corner=(0mm, -14.36666mm, -0.05mm), y_size=7.03333mm, z_size=0.1mm)
  C4_5.sweep_around_axis(axis=Z, angle=90deg, segments=15)
  C4_5.move(25.4mm, -5.1mm, 1.25mm)
  ToolC4_5_1 = box(corner=(39.76666mm, -5.1mm, 1.2mm), size=(-7.03333mm, 10.2mm, 0.1mm))
  ToolC4_5_2 = rectangle(corner=(14.36666mm, 0mm, -0.05mm), z_size=0.1mm, x_size=-7.03333mm)
  ToolC4_5_2.sweep_around_axis(axis=Z, angle=90deg, segments=15)
  ToolC4_5_2.move(25.4mm, 5.1mm, 1.25mm)
  ToolC4_5_3 = box(corner=(25.4mm, 19.46666mm, 1.2mm), size=(-50.8mm, -7.03333mm, 0.1mm))
  ToolC4_5_4 = rectangle(corner=(0mm, 14.36666mm, -0.05mm), y_size=-7.03333mm, z_size=0.1mm)
  ToolC4_5_4.sweep_around_axis(axis=Z, angle=90deg, segments=15)
  ToolC4_5_4.move(-25.4mm, 5.1mm, 1.25mm)
  ToolC4_5_5 = box(corner=(-39.76666mm, 5.1mm, 1.2mm), size=(7.03333mm, -10.2mm, 0.1mm))
  ToolC4_5_6 = rectangle(corner=(-14.36666mm, 0mm, -0.05mm), z_size=0.1mm, x_size=7.03333mm)
  ToolC4_5_6.sweep_around_axis(axis=Z, angle=90deg, segments=15)
  ToolC4_5_6.move(-25.4mm, -5.1mm, 1.25mm)
  ToolC4_5_7 = box(corner=(-25.4mm, -19.46666mm, 1.2mm), size=(50.8mm, 7.03333mm, 0.1mm))
  C4_5.unite(ToolC4_5_1..ToolC4_5_7)
  C4_4 [CondMat4_2, surface CondMat4_2_surface] = rectangle(corner=(0mm, -21.45mm, -0.05mm), y_size=7.03333mm, z_size=0.1mm)
  C4_4.sweep_around_axis(axis=Z, angle=90deg, segments=15)
  C4_4.move(25.4mm, -5.1mm, 1.25mm)
  ToolC4_4_1 = box(corner=(46.85mm, -5.1mm, 1.2mm), size=(-7.03333mm, 10.2mm, 0.1mm))
  ToolC4_4_2 = rectangle(corner=(21.45mm, 0mm, -0.05mm), z_size=0.1mm, x_size=-7.03333mm)
  ToolC4_4_2.sweep_around_axis(axis=Z, angle=90deg, segments=15)
  ToolC4_4_2.move(25.4mm, 5.1mm, 1.25mm)
  ToolC4_4_3 = box(corner=(25.4mm, 26.55mm, 1.2mm), size=(-50.8mm, -7.03333mm, 0.1mm))
  ToolC4_4_4 = rectangle(corner=(0mm, 21.45mm, -0.05mm), y_size=-7.03333mm, z_size=0.1mm)
  ToolC4_4_4.sweep_around_axis(axis=Z, angle=90deg, segments=15)
  ToolC4_4_4.move(-25.4mm, 5.1mm, 1.25mm)
  ToolC4_4_5 = box(corner=(-46.85mm, 5.1mm, 1.2mm), size=(7.03333mm, -10.2mm, 0.1mm))
  ToolC4_4_6 = rectangle(corner=(-21.45mm, 0mm, -0.05mm), z_size=0.1mm, x_size=7.03333mm)
  ToolC4_4_6.sweep_around_axis(axis=Z, angle=90deg, segments=15)
  ToolC4_4_6.move(-25.4mm, -5.1mm, 1.25mm)
  ToolC4_4_7 = box(corner=(-25.4mm, -26.55mm, 1.2mm), size=(50.8mm, 7.03333mm, 0.1mm))
  C4_4.unite(ToolC4_4_1..ToolC4_4_7)
  C4_9 [CondMat4_3, surface CondMat4_3_surface] = rectangle(corner=(0mm, -7.28333mm, -0.05mm), y_size=7.03333mm, z_size=0.1mm)
  C4_9.sweep_around_axis(axis=Z, angle=90deg, segments=15)
  C4_9.move(25.4mm, -5.1mm, 1.05mm)
  ToolC4_9_1 = box(corner=(32.68333mm, -5.1mm, 1mm), size=(-7.03333mm, 10.2mm, 0.1mm))
  ToolC4_9_2 = rectangle(corner=(7.28333mm, 0mm, -0.05mm), z_size=0.1mm, x_size=-7.03333mm)
  ToolC4_9_2.sweep_around_axis(axis=Z, angle=90deg, segments=15)
  ToolC4_9_2.move(25.4mm, 5.1mm, 1.05mm)
  ToolC4_9_3 = box(corner=(25.4mm, 12.38333mm, 1mm), size=(-50.8mm, -7.03333mm, 0.1mm))
  ToolC4_9_4 = rectangle(corner=(0mm, 7.28333mm, -0.05mm), y_size=-7.03333mm, z_size=0.1mm)
  ToolC4_9_4.sweep_around_axis(axis=Z, angle=90deg, segments=15)
  ToolC4_9_4.move(-25.4mm, 5.1mm, 1.05mm)
  ToolC4_9_5 = box(corner=(-32.68333mm, 5.1mm, 1mm), size=(7.03333mm, -10.2mm, 0.1mm))
  ToolC4_9_6 = rectangle(corner=(-7.28333mm, 0mm, -0.05mm), z_size=0.1mm, x_size=7.03333mm)
  ToolC4_9_6.sweep_around_axis(axis=Z, angle=90deg, segments=15)
  ToolC4_9_6.move(-25.4mm, -5.1mm, 1.05mm)
  ToolC4_9_7 = box(corner=(-25.4mm, -12.38333mm, 1mm), size=(50.8mm, 7.03333mm, 0.1mm))
  C4_9.unite(ToolC4_9_1..ToolC4_9_7)
  C4_8 [CondMat4_3, surface CondMat4_3_surface] = rectangle(corner=(0mm, -14.36666mm, -0.05mm), y_size=7.03333mm, z_size=0.1mm)
  C4_8.sweep_around_axis(axis=Z, angle=90deg, segments=15)
  C4_8.move(25.4mm, -5.1mm, 1.05mm)
  ToolC4_8_1 = box(corner=(39.76666mm, -5.1mm, 1mm), size=(-7.03333mm, 10.2mm, 0.1mm))
  ToolC4_8_2 = rectangle(corner=(14.36666mm, 0mm, -0.05mm), z_size=0.1mm, x_size=-7.03333mm)
  ToolC4_8_2.sweep_around_axis(axis=Z, angle=90deg, segments=15)
  ToolC4_8_2.move(25.4mm, 5.1mm, 1.05mm)
  ToolC4_8_3 = box(corner=(25.4mm, 19.46666mm, 1mm), size=(-50.8mm, -7.03333mm, 0.1mm))
  ToolC4_8_4 = rectangle(corner=(0mm, 14.36666mm, -0.05mm), y_size=-7.03333mm, z_size=0.1mm)
  ToolC4_8_4.sweep_around_axis(axis=Z, angle=90deg, segments=15)
  ToolC4_8_4.move(-25.4mm, 5.1mm, 1.05mm)
  ToolC4_8_5 = box(corner=(-39.76666mm, 5.1mm, 1mm), size=(7.03333mm, -10.2mm, 0.1mm))
  ToolC4_8_6 = rectangle(corner=(-14.36666mm, 0mm, -0.05mm), z_size=0.1mm, x_size=7.03333mm)
  ToolC4_8_6.sweep_around_axis(axis=Z, angle=90deg, segments=15)
  ToolC4_8_6.move(-25.4mm, -5.1mm, 1.05mm)
  ToolC4_8_7 = box(corner=(-25.4mm, -19.46666mm, 1mm), size=(50.8mm, 7.03333mm, 0.1mm))
  C4_8.unite(ToolC4_8_1..ToolC4_8_7)
  C4_7 [CondMat4_3, surface CondMat4_3_surface] = rectangle(corner=(0mm, -21.45mm, -0.05mm), y_size=7.03333mm, z_size=0.1mm)
  C4_7.sweep_around_axis(axis=Z, angle=90deg, segments=15)
  C4_7.move(25.4mm, -5.1mm, 1.05mm)
  ToolC4_7_1 = box(corner=(46.85mm, -5.1mm, 1mm), size=(-7.03333mm, 10.2mm, 0.1mm))
  ToolC4_7_2 = rectangle(corner=(21.45mm, 0mm, -0.05mm), z_size=0.1mm, x_size=-7.03333mm)
  ToolC4_7_2.sweep_around_axis(axis=Z, angle=90deg, segments=15)
  ToolC4_7_2.move(25.4mm, 5.1mm, 1.05mm)
  ToolC4_7_3 = box(corner=(25.4mm, 26.55mm, 1mm), size=(-50.8mm, -7.03333mm, 0.1mm))
  ToolC4_7_4 = rectangle(corner=(0mm, 21.45mm, -0.05mm), y_size=-7.03333mm, z_size=0.1mm)
  ToolC4_7_4.sweep_around_axis(axis=Z, angle=90deg, segments=15)
  ToolC4_7_4.move(-25.4mm, 5.1mm, 1.05mm)
  ToolC4_7_5 = box(corner=(-46.85mm, 5.1mm, 1mm), size=(7.03333mm, -10.2mm, 0.1mm))
  ToolC4_7_6 = rectangle(corner=(-21.45mm, 0mm, -0.05mm), z_size=0.1mm, x_size=7.03333mm)
  ToolC4_7_6.sweep_around_axis(axis=Z, angle=90deg, segments=15)
  ToolC4_7_6.move(-25.4mm, -5.1mm, 1.05mm)
  ToolC4_7_7 = box(corner=(-25.4mm, -26.55mm, 1mm), size=(50.8mm, 7.03333mm, 0.1mm))
  C4_7.unite(ToolC4_7_1..ToolC4_7_7)
  C4_12 [CondMat4_4, surface CondMat4_4_surface] = rectangle(corner=(0mm, -7.28333mm, -0.05mm), y_size=7.03333mm, z_size=0.1mm)
  C4_12.sweep_around_axis(axis=Z, angle=90deg, segments=15)
  C4_12.move(25.4mm, -5.1mm, 0.85mm)
  ToolC4_12_1 = box(corner=(32.68333mm, -5.1mm, 0.8mm), size=(-7.03333mm, 10.2mm, 0.1mm))
  ToolC4_12_2 = rectangle(corner=(7.28333mm, 0mm, -0.05mm), z_size=0.1mm, x_size=-7.03333mm)
  ToolC4_12_2.sweep_around_axis(axis=Z, angle=90deg, segments=15)
  ToolC4_12_2.move(25.4mm, 5.1mm, 0.85mm)
  ToolC4_12_3 = box(corner=(25.4mm, 12.38333mm, 0.8mm), size=(-50.8mm, -7.03333mm, 0.1mm))
  ToolC4_12_4 = rectangle(corner=(0mm, 7.28333mm, -0.05mm), y_size=-7.03333mm, z_size=0.1mm)
  ToolC4_12_4.sweep_around_axis(axis=Z, angle=90deg, segments=15)
  ToolC4_12_4.move(-25.4mm, 5.1mm, 0.85mm)
  ToolC4_12_5 = box(corner=(-32.68333mm, 5.1mm, 0.8mm), size=(7.03333mm, -10.2mm, 0.1mm))
  ToolC4_12_6 = rectangle(corner=(-7.28333mm, 0mm, -0.05mm), z_size=0.1mm, x_size=7.03333mm)
  ToolC4_12_6.sweep_around_axis(axis=Z, angle=90deg, segments=15)
  ToolC4_12_6.move(-25.4mm, -5.1mm, 0.85mm)
  ToolC4_12_7 = box(corner=(-25.4mm, -12.38333mm, 0.8mm), size=(50.8mm, 7.03333mm, 0.1mm))
  C4_12.unite(ToolC4_12_1..ToolC4_12_7)
  C4_11 [CondMat4_4, surface CondMat4_4_surface] = rectangle(corner=(0mm, -14.36666mm, -0.05mm), y_size=7.03333mm, z_size=0.1mm)
  C4_11.sweep_around_axis(axis=Z, angle=90deg, segments=15)
  C4_11.move(25.4mm, -5.1mm, 0.85mm)
  ToolC4_11_1 = box(corner=(39.76666mm, -5.1mm, 0.8mm), size=(-7.03333mm, 10.2mm, 0.1mm))
  ToolC4_11_2 = rectangle(corner=(14.36666mm, 0mm, -0.05mm), z_size=0.1mm, x_size=-7.03333mm)
  ToolC4_11_2.sweep_around_axis(axis=Z, angle=90deg, segments=15)
  ToolC4_11_2.move(25.4mm, 5.1mm, 0.85mm)
  ToolC4_11_3 = box(corner=(25.4mm, 19.46666mm, 0.8mm), size=(-50.8mm, -7.03333mm, 0.1mm))
  ToolC4_11_4 = rectangle(corner=(0mm, 14.36666mm, -0.05mm), y_size=-7.03333mm, z_size=0.1mm)
  ToolC4_11_4.sweep_around_axis(axis=Z, angle=90deg, segments=15)
  ToolC4_11_4.move(-25.4mm, 5.1mm, 0.85mm)
  ToolC4_11_5 = box(corner=(-39.76666mm, 5.1mm, 0.8mm), size=(7.03333mm, -10.2mm, 0.1mm))
  ToolC4_11_6 = rectangle(corner=(-14.36666mm, 0mm, -0.05mm), z_size=0.1mm, x_size=7.03333mm)
  ToolC4_11_6.sweep_around_axis(axis=Z, angle=90deg, segments=15)
  ToolC4_11_6.move(-25.4mm, -5.1mm, 0.85mm)
  ToolC4_11_7 = box(corner=(-25.4mm, -19.46666mm, 0.8mm), size=(50.8mm, 7.03333mm, 0.1mm))
  C4_11.unite(ToolC4_11_1..ToolC4_11_7)
  C4_10 [CondMat4_4, surface CondMat4_4_surface] = rectangle(corner=(0mm, -21.45mm, -0.05mm), y_size=7.03333mm, z_size=0.1mm)
  C4_10.sweep_around_axis(axis=Z, angle=90deg, segments=15)
  C4_10.move(25.4mm, -5.1mm, 0.85mm)
  ToolC4_10_1 = box(corner=(46.85mm, -5.1mm, 0.8mm), size=(-7.03333mm, 10.2mm, 0.1mm))
  ToolC4_10_2 = rectangle(corner=(21.45mm, 0mm, -0.05mm), z_size=0.1mm, x_size=-7.03333mm)
  ToolC4_10_2.sweep_around_axis(axis=Z, angle=90deg, segments=15)
  ToolC4_10_2.move(25.4mm, 5.1mm, 0.85mm)
  ToolC4_10_3 = box(corner=(25.4mm, 26.55mm, 0.8mm), size=(-50.8mm, -7.03333mm, 0.1mm))
  ToolC4_10_4 = rectangle(corner=(0mm, 21.45mm, -0.05mm), y_size=-7.03333mm, z_size=0.1mm)
  ToolC4_10_4.sweep_around_axis(axis=Z, angle=90deg, segments=15)
  ToolC4_10_4.move(-25.4mm, 5.1mm, 0.85mm)
  ToolC4_10_5 = box(corner=(-46.85mm, 5.1mm, 0.8mm), size=(7.03333mm, -10.2mm, 0.1mm))
  ToolC4_10_6 = rectangle(corner=(-21.45mm, 0mm, -0.05mm), z_size=0.1mm, x_size=7.03333mm)
  ToolC4_10_6.sweep_around_axis(axis=Z, angle=90deg, segments=15)
  ToolC4_10_6.move(-25.4mm, -5.1mm, 0.85mm)
  ToolC4_10_7 = box(corner=(-25.4mm, -26.55mm, 0.8mm), size=(50.8mm, 7.03333mm, 0.1mm))
  C4_10.unite(ToolC4_10_1..ToolC4_10_7)
  C4_15 [CondMat4_5, surface CondMat4_5_surface] = rectangle(corner=(0mm, -7.28333mm, -0.05mm), y_size=7.03333mm, z_size=0.1mm)
  C4_15.sweep_around_axis(axis=Z, angle=90deg, segments=15)
  C4_15.move(25.4mm, -5.1mm, 0.65mm)
  ToolC4_15_1 = box(corner=(32.68333mm, -5.1mm, 0.6mm), size=(-7.03333mm, 10.2mm, 0.1mm))
  ToolC4_15_2 = rectangle(corner=(7.28333mm, 0mm, -0.05mm), z_size=0.1mm, x_size=-7.03333mm)
  ToolC4_15_2.sweep_around_axis(axis=Z, angle=90deg, segments=15)
  ToolC4_15_2.move(25.4mm, 5.1mm, 0.65mm)
  ToolC4_15_3 = box(corner=(25.4mm, 12.38333mm, 0.6mm), size=(-50.8mm, -7.03333mm, 0.1mm))
  ToolC4_15_4 = rectangle(corner=(0mm, 7.28333mm, -0.05mm), y_size=-7.03333mm, z_size=0.1mm)
  ToolC4_15_4.sweep_around_axis(axis=Z, angle=90deg, segments=15)
  ToolC4_15_4.move(-25.4mm, 5.1mm, 0.65mm)
  ToolC4_15_5 = box(corner=(-32.68333mm, 5.1mm, 0.6mm), size=(7.03333mm, -10.2mm, 0.1mm))
  ToolC4_15_6 = rectangle(corner=(-7.28333mm, 0mm, -0.05mm), z_size=0.1mm, x_size=7.03333mm)
  ToolC4_15_6.sweep_around_axis(axis=Z, angle=90deg, segments=15)
  ToolC4_15_6.move(-25.4mm, -5.1mm, 0.65mm)
  ToolC4_15_7 = box(corner=(-25.4mm, -12.38333mm, 0.6mm), size=(50.8mm, 7.03333mm, 0.1mm))
  C4_15.unite(ToolC4_15_1..ToolC4_15_7)
  C4_14 [CondMat4_5, surface CondMat4_5_surface] = rectangle(corner=(0mm, -14.36666mm, -0.05mm), y_size=7.03333mm, z_size=0.1mm)
  C4_14.sweep_around_axis(axis=Z, angle=90deg, segments=15)
  C4_14.move(25.4mm, -5.1mm, 0.65mm)
  ToolC4_14_1 = box(corner=(39.76666mm, -5.1mm, 0.6mm), size=(-7.03333mm, 10.2mm, 0.1mm))
  ToolC4_14_2 = rectangle(corner=(14.36666mm, 0mm, -0.05mm), z_size=0.1mm, x_size=-7.03333mm)
  ToolC4_14_2.sweep_around_axis(axis=Z, angle=90deg, segments=15)
  ToolC4_14_2.move(25.4mm, 5.1mm, 0.65mm)
  ToolC4_14_3 = box(corner=(25.4mm, 19.46666mm, 0.6mm), size=(-50.8mm, -7.03333mm, 0.1mm))
  ToolC4_14_4 = rectangle(corner=(0mm, 14.36666mm, -0.05mm), y_size=-7.03333mm, z_size=0.1mm)
  ToolC4_14_4.sweep_around_axis(axis=Z, angle=90deg, segments=15)
  ToolC4_14_4.move(-25.4mm, 5.1mm, 0.65mm)
  ToolC4_14_5 = box(corner=(-39.76666mm, 5.1mm, 0.6mm), size=(7.03333mm, -10.2mm, 0.1mm))
  ToolC4_14_6 = rectangle(corner=(-14.36666mm, 0mm, -0.05mm), z_size=0.1mm, x_size=7.03333mm)
  ToolC4_14_6.sweep_around_axis(axis=Z, angle=90deg, segments=15)
  ToolC4_14_6.move(-25.4mm, -5.1mm, 0.65mm)
  ToolC4_14_7 = box(corner=(-25.4mm, -19.46666mm, 0.6mm), size=(50.8mm, 7.03333mm, 0.1mm))
  C4_14.unite(ToolC4_14_1..ToolC4_14_7)
  C4_13 [CondMat4_5, surface CondMat4_5_surface] = rectangle(corner=(0mm, -21.45mm, -0.05mm), y_size=7.03333mm, z_size=0.1mm)
  C4_13.sweep_around_axis(axis=Z, angle=90deg, segments=15)
  C4_13.move(25.4mm, -5.1mm, 0.65mm)
  ToolC4_13_1 = box(corner=(46.85mm, -5.1mm, 0.6mm), size=(-7.03333mm, 10.2mm, 0.1mm))
  ToolC4_13_2 = rectangle(corner=(21.45mm, 0mm, -0.05mm), z_size=0.1mm, x_size=-7.03333mm)
  ToolC4_13_2.sweep_around_axis(axis=Z, angle=90deg, segments=15)
  ToolC4_13_2.move(25.4mm, 5.1mm, 0.65mm)
  ToolC4_13_3 = box(corner=(25.4mm, 26.55mm, 0.6mm), size=(-50.8mm, -7.03333mm, 0.1mm))
  ToolC4_13_4 = rectangle(corner=(0mm, 21.45mm, -0.05mm), y_size=-7.03333mm, z_size=0.1mm)
  ToolC4_13_4.sweep_around_axis(axis=Z, angle=90deg, segments=15)
  ToolC4_13_4.move(-25.4mm, 5.1mm, 0.65mm)
  ToolC4_13_5 = box(corner=(-46.85mm, 5.1mm, 0.6mm), size=(7.03333mm, -10.2mm, 0.1mm))
  ToolC4_13_6 = rectangle(corner=(-21.45mm, 0mm, -0.05mm), z_size=0.1mm, x_size=7.03333mm)
  ToolC4_13_6.sweep_around_axis(axis=Z, angle=90deg, segments=15)
  ToolC4_13_6.move(-25.4mm, -5.1mm, 0.65mm)
  ToolC4_13_7 = box(corner=(-25.4mm, -26.55mm, 0.6mm), size=(50.8mm, 7.03333mm, 0.1mm))
  C4_13.unite(ToolC4_13_1..ToolC4_13_7)
  C4_18 [CondMat4_6, surface CondMat4_6_surface] = rectangle(corner=(0mm, -7.28333mm, -0.05mm), y_size=7.03333mm, z_size=0.1mm)
  C4_18.sweep_around_axis(axis=Z, angle=90deg, segments=15)
  C4_18.move(25.4mm, -5.1mm, 0.45mm)
  ToolC4_18_1 = box(corner=(32.68333mm, -5.1mm, 0.4mm), size=(-7.03333mm, 10.2mm, 0.1mm))
  ToolC4_18_2 = rectangle(corner=(7.28333mm, 0mm, -0.05mm), z_size=0.1mm, x_size=-7.03333mm)
  ToolC4_18_2.sweep_around_axis(axis=Z, angle=90deg, segments=15)
  ToolC4_18_2.move(25.4mm, 5.1mm, 0.45mm)
  ToolC4_18_3 = box(corner=(25.4mm, 12.38333mm, 0.4mm), size=(-50.8mm, -7.03333mm, 0.1mm))
  ToolC4_18_4 = rectangle(corner=(0mm, 7.28333mm, -0.05mm), y_size=-7.03333mm, z_size=0.1mm)
  ToolC4_18_4.sweep_around_axis(axis=Z, angle=90deg, segments=15)
  ToolC4_18_4.move(-25.4mm, 5.1mm, 0.45mm)
  ToolC4_18_5 = box(corner=(-32.68333mm, 5.1mm, 0.4mm), size=(7.03333mm, -10.2mm, 0.1mm))
  ToolC4_18_6 = rectangle(corner=(-7.28333mm, 0mm, -0.05mm), z_size=0.1mm, x_size=7.03333mm)
  ToolC4_18_6.sweep_around_axis(axis=Z, angle=90deg, segments=15)
  ToolC4_18_6.move(-25.4mm, -5.1mm, 0.45mm)
  ToolC4_18_7 = box(corner=(-25.4mm, -12.38333mm, 0.4mm), size=(50.8mm, 7.03333mm, 0.1mm))
  C4_18.unite(ToolC4_18_1..ToolC4_18_7)
  C4_17 [CondMat4_6, surface CondMat4_6_surface] = rectangle(corner=(0mm, -14.36666mm, -0.05mm), y_size=7.03333mm, z_size=0.1mm)
  C4_17.sweep_around_axis(axis=Z, angle=90deg, segments=15)
  C4_17.move(25.4mm, -5.1mm, 0.45mm)
  ToolC4_17_1 = box(corner=(39.76666mm, -5.1mm, 0.4mm), size=(-7.03333mm, 10.2mm, 0.1mm))
  ToolC4_17_2 = rectangle(corner=(14.36666mm, 0mm, -0.05mm), z_size=0.1mm, x_size=-7.03333mm)
  ToolC4_17_2.sweep_around_axis(axis=Z, angle=90deg, segments=15)
  ToolC4_17_2.move(25.4mm, 5.1mm, 0.45mm)
  ToolC4_17_3 = box(corner=(25.4mm, 19.46666mm, 0.4mm), size=(-50.8mm, -7.03333mm, 0.1mm))
  ToolC4_17_4 = rectangle(corner=(0mm, 14.36666mm, -0.05mm), y_size=-7.03333mm, z_size=0.1mm)
  ToolC4_17_4.sweep_around_axis(axis=Z, angle=90deg, segments=15)
  ToolC4_17_4.move(-25.4mm, 5.1mm, 0.45mm)
  ToolC4_17_5 = box(corner=(-39.76666mm, 5.1mm, 0.4mm), size=(7.03333mm, -10.2mm, 0.1mm))
  ToolC4_17_6 = rectangle(corner=(-14.36666mm, 0mm, -0.05mm), z_size=0.1mm, x_size=7.03333mm)
  ToolC4_17_6.sweep_around_axis(axis=Z, angle=90deg, segments=15)
  ToolC4_17_6.move(-25.4mm, -5.1mm, 0.45mm)
  ToolC4_17_7 = box(corner=(-25.4mm, -19.46666mm, 0.4mm), size=(50.8mm, 7.03333mm, 0.1mm))
  C4_17.unite(ToolC4_17_1..ToolC4_17_7)
  C4_16 [CondMat4_6, surface CondMat4_6_surface] = rectangle(corner=(0mm, -21.45mm, -0.05mm), y_size=7.03333mm, z_size=0.1mm)
  C4_16.sweep_around_axis(axis=Z, angle=90deg, segments=15)
  C4_16.move(25.4mm, -5.1mm, 0.45mm)
  ToolC4_16_1 = box(corner=(46.85mm, -5.1mm, 0.4mm), size=(-7.03333mm, 10.2mm, 0.1mm))
  ToolC4_16_2 = rectangle(corner=(21.45mm, 0mm, -0.05mm), z_size=0.1mm, x_size=-7.03333mm)
  ToolC4_16_2.sweep_around_axis(axis=Z, angle=90deg, segments=15)
  ToolC4_16_2.move(25.4mm, 5.1mm, 0.45mm)
  ToolC4_16_3 = box(corner=(25.4mm, 26.55mm, 0.4mm), size=(-50.8mm, -7.03333mm, 0.1mm))
  ToolC4_16_4 = rectangle(corner=(0mm, 21.45mm, -0.05mm), y_size=-7.03333mm, z_size=0.1mm)
  ToolC4_16_4.sweep_around_axis(axis=Z, angle=90deg, segments=15)
  ToolC4_16_4.move(-25.4mm, 5.1mm, 0.45mm)
  ToolC4_16_5 = box(corner=(-46.85mm, 5.1mm, 0.4mm), size=(7.03333mm, -10.2mm, 0.1mm))
  ToolC4_16_6 = rectangle(corner=(-21.45mm, 0mm, -0.05mm), z_size=0.1mm, x_size=7.03333mm)
  ToolC4_16_6.sweep_around_axis(axis=Z, angle=90deg, segments=15)
  ToolC4_16_6.move(-25.4mm, -5.1mm, 0.45mm)
  ToolC4_16_7 = box(corner=(-25.4mm, -26.55mm, 0.4mm), size=(50.8mm, 7.03333mm, 0.1mm))
  C4_16.unite(ToolC4_16_1..ToolC4_16_7)
  C5_1 [CondMat5_1, surface CondMat5_1_surface] = rectangle(corner=(0mm, -21.45mm, -0.05mm), y_size=21.2mm, z_size=0.1mm)
  C5_1.sweep_around_axis(axis=Z, angle=90deg, segments=15)
  C5_1.move(25.4mm, -5.1mm, 0.25mm)
  ToolC5_1_1 = box(corner=(46.85mm, -5.1mm, 0.2mm), size=(-21.2mm, 10.2mm, 0.1mm))
  ToolC5_1_2 = rectangle(corner=(21.45mm, 0mm, -0.05mm), z_size=0.1mm, x_size=-21.2mm)
  ToolC5_1_2.sweep_around_axis(axis=Z, angle=90deg, segments=15)
  ToolC5_1_2.move(25.4mm, 5.1mm, 0.25mm)
  ToolC5_1_3 = box(corner=(25.4mm, 26.55mm, 0.2mm), size=(-50.8mm, -21.2mm, 0.1mm))
  ToolC5_1_4 = rectangle(corner=(0mm, 21.45mm, -0.05mm), y_size=-21.2mm, z_size=0.1mm)
  ToolC5_1_4.sweep_around_axis(axis=Z, angle=90deg, segments=15)
  ToolC5_1_4.move(-25.4mm, 5.1mm, 0.25mm)
  ToolC5_1_5 = box(corner=(-46.85mm, 5.1mm, 0.2mm), size=(21.2mm, -10.2mm, 0.1mm))
  ToolC5_1_6 = rectangle(corner=(-21.45mm, 0mm, -0.05mm), z_size=0.1mm, x_size=21.2mm)
  ToolC5_1_6.sweep_around_axis(axis=Z, angle=90deg, segments=15)
  ToolC5_1_6.move(-25.4mm, -5.1mm, 0.25mm)
  ToolC5_1_7 = box(corner=(-25.4mm, -26.55mm, 0.2mm), size=(50.8mm, 21.2mm, 0.1mm))
  C5_1.unite(ToolC5_1_1..ToolC5_1_7)
  C5_2 [CondMat5_2, surface CondMat5_2_surface] = rectangle(corner=(0mm, -21.45mm, -0.05mm), y_size=21.2mm, z_size=0.1mm)
  C5_2.sweep_around_axis(axis=Z, angle=90deg, segments=15)
  C5_2.move(25.4mm, -5.1mm, 0.05mm)
  ToolC5_2_1 = box(corner=(46.85mm, -5.1mm, 0mm), size=(-21.2mm, 10.2mm, 0.1mm))
  ToolC5_2_2 = rectangle(corner=(21.45mm, 0mm, -0.05mm), z_size=0.1mm, x_size=-21.2mm)
  ToolC5_2_2.sweep_around_axis(axis=Z, angle=90deg, segments=15)
  ToolC5_2_2.move(25.4mm, 5.1mm, 0.05mm)
  ToolC5_2_3 = box(corner=(25.4mm, 26.55mm, 0mm), size=(-50.8mm, -21.2mm, 0.1mm))
  ToolC5_2_4 = rectangle(corner=(0mm, 21.45mm, -0.05mm), y_size=-21.2mm, z_size=0.1mm)
  ToolC5_2_4.sweep_around_axis(axis=Z, angle=90deg, segments=15)
  ToolC5_2_4.move(-25.4mm, 5.1mm, 0.05mm)
  ToolC5_2_5 = box(corner=(-46.85mm, 5.1mm, 0mm), size=(21.2mm, -10.2mm, 0.1mm))
  ToolC5_2_6 = rectangle(corner=(-21.45mm, 0mm, -0.05mm), z_size=0.1mm, x_size=21.2mm)
  ToolC5_2_6.sweep_around_axis(axis=Z, angle=90deg, segments=15)
  ToolC5_2_6.move(-25.4mm, -5.1mm, 0.05mm)
  ToolC5_2_7 = box(corner=(-25.4mm, -26.55mm, 0mm), size=(50.8mm, 21.2mm, 0.1mm))
  C5_2.unite(ToolC5_2_1..ToolC5_2_7)
  C6_1 [CondMat6_1, surface CondMat6_1_surface] = rectangle(corner=(0mm, -21.45mm, -0.05mm), y_size=21.2mm, z_size=0.1mm)
  C6_1.sweep_around_axis(axis=Z, angle=90deg, segments=15)
  C6_1.move(25.4mm, -5.1mm, -0.15mm)
  ToolC6_1_1 = box(corner=(46.85mm, -5.1mm, -0.2mm), size=(-21.2mm, 10.2mm, 0.1mm))
  ToolC6_1_2 = rectangle(corner=(21.45mm, 0mm, -0.05mm), z_size=0.1mm, x_size=-21.2mm)
  ToolC6_1_2.sweep_around_axis(axis=Z, angle=90deg, segments=15)
  ToolC6_1_2.move(25.4mm, 5.1mm, -0.15mm)
  ToolC6_1_3 = box(corner=(25.4mm, 26.55mm, -0.2mm), size=(-50.8mm, -21.2mm, 0.1mm))
  ToolC6_1_4 = rectangle(corner=(0mm, 21.45mm, -0.05mm), y_size=-21.2mm, z_size=0.1mm)
  ToolC6_1_4.sweep_around_axis(axis=Z, angle=90deg, segments=15)
  ToolC6_1_4.move(-25.4mm, 5.1mm, -0.15mm)
  ToolC6_1_5 = box(corner=(-46.85mm, 5.1mm, -0.2mm), size=(21.2mm, -10.2mm, 0.1mm))
  ToolC6_1_6 = rectangle(corner=(-21.45mm, 0mm, -0.05mm), z_size=0.1mm, x_size=21.2mm)
  ToolC6_1_6.sweep_around_axis(axis=Z, angle=90deg, segments=15)
  ToolC6_1_6.move(-25.4mm, -5.1mm, -0.15mm)
  ToolC6_1_7 = box(corner=(-25.4mm, -26.55mm, -0.2mm), size=(50.8mm, 21.2mm, 0.1mm))
  C6_1.unite(ToolC6_1_1..ToolC6_1_7)
  C6_2 [CondMat6_2, surface CondMat6_2_surface] = rectangle(corner=(0mm, -21.45mm, -0.05mm), y_size=21.2mm, z_size=0.1mm)
  C6_2.sweep_around_axis(axis=Z, angle=90deg, segments=15)
  C6_2.move(25.4mm, -5.1mm, -0.35mm)
  ToolC6_2_1 = box(corner=(46.85mm, -5.1mm, -0.4mm), size=(-21.2mm, 10.2mm, 0.1mm))
  ToolC6_2_2 = rectangle(corner=(21.45mm, 0mm, -0.05mm), z_size=0.1mm, x_size=-21.2mm)
  ToolC6_2_2.sweep_around_axis(axis=Z, angle=90deg, segments=15)
  ToolC6_2_2.move(25.4mm, 5.1mm, -0.35mm)
  ToolC6_2_3 = box(corner=(25.4mm, 26.55mm, -0.4mm), size=(-50.8mm, -21.2mm, 0.1mm))
  ToolC6_2_4 = rectangle(corner=(0mm, 21.45mm, -0.05mm), y_size=-21.2mm, z_size=0.1mm)
  ToolC6_2_4.sweep_around_axis(axis=Z, angle=90deg, segments=15)
  ToolC6_2_4.move(-25.4mm, 5.1mm, -0.35mm)
  ToolC6_2_5 = box(corner=(-46.85mm, 5.1mm, -0.4mm), size=(21.2mm, -10.2mm, 0.1mm))
  ToolC6_2_6 = rectangle(corner=(-21.45mm, 0mm, -0.05mm), z_size=0.1mm, x_size=21.2mm)
  ToolC6_2_6.sweep_around_axis(axis=Z, angle=90deg, segments=15)
  ToolC6_2_6.move(-25.4mm, -5.1mm, -0.35mm)
  ToolC6_2_7 = box(corner=(-25.4mm, -26.55mm, -0.4mm), size=(50.8mm, 21.2mm, 0.1mm))
  C6_2.unite(ToolC6_2_1..ToolC6_2_7)
  C7_1 [CondMat7_1, surface CondMat7_1_surface] = rectangle(corner=(0mm, -21.45mm, -0.05mm), y_size=21.2mm, z_size=0.1mm)
  C7_1.sweep_around_axis(axis=Z, angle=90deg, segments=15)
  C7_1.move(25.4mm, -5.1mm, -0.55mm)
  ToolC7_1_1 = box(corner=(46.85mm, -5.1mm, -0.6mm), size=(-21.2mm, 10.2mm, 0.1mm))
  ToolC7_1_2 = rectangle(corner=(21.45mm, 0mm, -0.05mm), z_size=0.1mm, x_size=-21.2mm)
  ToolC7_1_2.sweep_around_axis(axis=Z, angle=90deg, segments=15)
  ToolC7_1_2.move(25.4mm, 5.1mm, -0.55mm)
  ToolC7_1_3 = box(corner=(25.4mm, 26.55mm, -0.6mm), size=(-50.8mm, -21.2mm, 0.1mm))
  ToolC7_1_4 = rectangle(corner=(0mm, 21.45mm, -0.05mm), y_size=-21.2mm, z_size=0.1mm)
  ToolC7_1_4.sweep_around_axis(axis=Z, angle=90deg, segments=15)
  ToolC7_1_4.move(-25.4mm, 5.1mm, -0.55mm)
  ToolC7_1_5 = box(corner=(-46.85mm, 5.1mm, -0.6mm), size=(21.2mm, -10.2mm, 0.1mm))
  ToolC7_1_6 = rectangle(corner=(-21.45mm, 0mm, -0.05mm), z_size=0.1mm, x_size=21.2mm)
  ToolC7_1_6.sweep_around_axis(axis=Z, angle=90deg, segments=15)
  ToolC7_1_6.move(-25.4mm, -5.1mm, -0.55mm)
  ToolC7_1_7 = box(corner=(-25.4mm, -26.55mm, -0.6mm), size=(50.8mm, 21.2mm, 0.1mm))
  C7_1.unite(ToolC7_1_1..ToolC7_1_7)
  C7_2 [CondMat7_2, surface CondMat7_2_surface] = rectangle(corner=(0mm, -21.45mm, -0.05mm), y_size=21.2mm, z_size=0.1mm)
  C7_2.sweep_around_axis(axis=Z, angle=90deg, segments=15)
  C7_2.move(25.4mm, -5.1mm, -0.75mm)
  ToolC7_2_1 = box(corner=(46.85mm, -5.1mm, -0.8mm), size=(-21.2mm, 10.2mm, 0.1mm))
  ToolC7_2_2 = rectangle(corner=(21.45mm, 0mm, -0.05mm), z_size=0.1mm, x_size=-21.2mm)
  ToolC7_2_2.sweep_around_axis(axis=Z, angle=90deg, segments=15)
  ToolC7_2_2.move(25.4mm, 5.1mm, -0.75mm)
  ToolC7_2_3 = box(corner=(25.4mm, 26.55mm, -0.8mm), size=(-50.8mm, -21.2mm, 0.1mm))
  ToolC7_2_4 = rectangle(corner=(0mm, 21.45mm, -0.05mm), y_size=-21.2mm, z_size=0.1mm)
  ToolC7_2_4.sweep_around_axis(axis=Z, angle=90deg, segments=15)
  ToolC7_2_4.move(-25.4mm, 5.1mm, -0.75mm)
  ToolC7_2_5 = box(corner=(-46.85mm, 5.1mm, -0.8mm), size=(21.2mm, -10.2mm, 0.1mm))
  ToolC7_2_6 = rectangle(corner=(-21.45mm, 0mm, -0.05mm), z_size=0.1mm, x_size=21.2mm)
  ToolC7_2_6.sweep_around_axis(axis=Z, angle=90deg, segments=15)
  ToolC7_2_6.move(-25.4mm, -5.1mm, -0.75mm)
  ToolC7_2_7 = box(corner=(-25.4mm, -26.55mm, -0.8mm), size=(50.8mm, 21.2mm, 0.1mm))
  C7_2.unite(ToolC7_2_1..ToolC7_2_7)
  C8_1 [CondMat8_1, surface CondMat8_1_surface] = rectangle(corner=(0mm, -21.45mm, -0.05mm), y_size=21.2mm, z_size=0.1mm)
  C8_1.sweep_around_axis(axis=Z, angle=90deg, segments=15)
  C8_1.move(25.4mm, -5.1mm, -0.95mm)
  ToolC8_1_1 = box(corner=(46.85mm, -5.1mm, -1mm), size=(-21.2mm, 10.2mm, 0.1mm))
  ToolC8_1_2 = rectangle(corner=(21.45mm, 0mm, -0.05mm), z_size=0.1mm, x_size=-21.2mm)
  ToolC8_1_2.sweep_around_axis(axis=Z, angle=90deg, segments=15)
  ToolC8_1_2.move(25.4mm, 5.1mm, -0.95mm)
  ToolC8_1_3 = box(corner=(25.4mm, 26.55mm, -1mm), size=(-50.8mm, -21.2mm, 0.1mm))
  ToolC8_1_4 = rectangle(corner=(0mm, 21.45mm, -0.05mm), y_size=-21.2mm, z_size=0.1mm)
  ToolC8_1_4.sweep_around_axis(axis=Z, angle=90deg, segments=15)
  ToolC8_1_4.move(-25.4mm, 5.1mm, -0.95mm)
  ToolC8_1_5 = box(corner=(-46.85mm, 5.1mm, -1mm), size=(21.2mm, -10.2mm, 0.1mm))
  ToolC8_1_6 = rectangle(corner=(-21.45mm, 0mm, -0.05mm), z_size=0.1mm, x_size=21.2mm)
  ToolC8_1_6.sweep_around_axis(axis=Z, angle=90deg, segments=15)
  ToolC8_1_6.move(-25.4mm, -5.1mm, -0.95mm)
  ToolC8_1_7 = box(corner=(-25.4mm, -26.55mm, -1mm), size=(50.8mm, 21.2mm, 0.1mm))
  C8_1.unite(ToolC8_1_1..ToolC8_1_7)
  C8_2 [CondMat8_2, surface CondMat8_2_surface] = rectangle(corner=(0mm, -21.45mm, -0.05mm), y_size=21.2mm, z_size=0.1mm)
  C8_2.sweep_around_axis(axis=Z, angle=90deg, segments=15)
  C8_2.move(25.4mm, -5.1mm, -1.15mm)
  ToolC8_2_1 = box(corner=(46.85mm, -5.1mm, -1.2mm), size=(-21.2mm, 10.2mm, 0.1mm))
  ToolC8_2_2 = rectangle(corner=(21.45mm, 0mm, -0.05mm), z_size=0.1mm, x_size=-21.2mm)
  ToolC8_2_2.sweep_around_axis(axis=Z, angle=90deg, segments=15)
  ToolC8_2_2.move(25.4mm, 5.1mm, -1.15mm)
  ToolC8_2_3 = box(corner=(25.4mm, 26.55mm, -1.2mm), size=(-50.8mm, -21.2mm, 0.1mm))
  ToolC8_2_4 = rectangle(corner=(0mm, 21.45mm, -0.05mm), y_size=-21.2mm, z_size=0.1mm)
  ToolC8_2_4.sweep_around_axis(axis=Z, angle=90deg, segments=15)
  ToolC8_2_4.move(-25.4mm, 5.1mm, -1.15mm)
  ToolC8_2_5 = box(corner=(-46.85mm, 5.1mm, -1.2mm), size=(21.2mm, -10.2mm, 0.1mm))
  ToolC8_2_6 = rectangle(corner=(-21.45mm, 0mm, -0.05mm), z_size=0.1mm, x_size=21.2mm)
  ToolC8_2_6.sweep_around_axis(axis=Z, angle=90deg, segments=15)
  ToolC8_2_6.move(-25.4mm, -5.1mm, -1.15mm)
  ToolC8_2_7 = box(corner=(-25.4mm, -26.55mm, -1.2mm), size=(50.8mm, 21.2mm, 0.1mm))
  C8_2.unite(ToolC8_2_1..ToolC8_2_7)
  C9_1 [CondMat9_1, surface CondMat9_1_surface] = rectangle(corner=(0mm, -21.45mm, -0.05mm), y_size=21.2mm, z_size=0.1mm)
  C9_1.sweep_around_axis(axis=Z, angle=90deg, segments=15)
  C9_1.move(25.4mm, -5.1mm, -1.35mm)
  ToolC9_1_1 = box(corner=(46.85mm, -5.1mm, -1.4mm), size=(-21.2mm, 10.2mm, 0.1mm))
  ToolC9_1_2 = rectangle(corner=(21.45mm, 0mm, -0.05mm), z_size=0.1mm, x_size=-21.2mm)
  ToolC9_1_2.sweep_around_axis(axis=Z, angle=90deg, segments=15)
  ToolC9_1_2.move(25.4mm, 5.1mm, -1.35mm)
  ToolC9_1_3 = box(corner=(25.4mm, 26.55mm, -1.4mm), size=(-50.8mm, -21.2mm, 0.1mm))
  ToolC9_1_4 = rectangle(corner=(0mm, 21.45mm, -0.05mm), y_size=-21.2mm, z_size=0.1mm)
  ToolC9_1_4.sweep_around_axis(axis=Z, angle=90deg, segments=15)
  ToolC9_1_4.move(-25.4mm, 5.1mm, -1.35mm)
  ToolC9_1_5 = box(corner=(-46.85mm, 5.1mm, -1.4mm), size=(21.2mm, -10.2mm, 0.1mm))
  ToolC9_1_6 = rectangle(corner=(-21.45mm, 0mm, -0.05mm), z_size=0.1mm, x_size=21.2mm)
  ToolC9_1_6.sweep_around_axis(axis=Z, angle=90deg, segments=15)
  ToolC9_1_6.move(-25.4mm, -5.1mm, -1.35mm)
  ToolC9_1_7 = box(corner=(-25.4mm, -26.55mm, -1.4mm), size=(50.8mm, 21.2mm, 0.1mm))
  C9_1.unite(ToolC9_1_1..ToolC9_1_7)
  C9_2 [CondMat9_2, surface CondMat9_2_surface] = rectangle(corner=(0mm, -21.45mm, -0.05mm), y_size=21.2mm, z_size=0.1mm)
  C9_2.sweep_around_axis(axis=Z, angle=90deg, segments=15)
  C9_2.move(25.4mm, -5.1mm, -1.55mm)
  ToolC9_2_1 = box(corner=(46.85mm, -5.1mm, -1.6mm), size=(-21.2mm, 10.2mm, 0.1mm))
  ToolC9_2_2 = rectangle(corner=(21.45mm, 0mm, -0.05mm), z_size=0.1mm, x_size=-21.2mm)
  ToolC9_2_2.sweep_around_axis(axis=Z, angle=90deg, segments=15)
  ToolC9_2_2.move(25.4mm, 5.1mm, -1.55mm)
  ToolC9_2_3 = box(corner=(25.4mm, 26.55mm, -1.6mm), size=(-50.8mm, -21.2mm, 0.1mm))
  ToolC9_2_4 = rectangle(corner=(0mm, 21.45mm, -0.05mm), y_size=-21.2mm, z_size=0.1mm)
  ToolC9_2_4.sweep_around_axis(axis=Z, angle=90deg, segments=15)
  ToolC9_2_4.move(-25.4mm, 5.1mm, -1.55mm)
  ToolC9_2_5 = box(corner=(-46.85mm, 5.1mm, -1.6mm), size=(21.2mm, -10.2mm, 0.1mm))
  ToolC9_2_6 = rectangle(corner=(-21.45mm, 0mm, -0.05mm), z_size=0.1mm, x_size=21.2mm)
  ToolC9_2_6.sweep_around_axis(axis=Z, angle=90deg, segments=15)
  ToolC9_2_6.move(-25.4mm, -5.1mm, -1.55mm)
  ToolC9_2_7 = box(corner=(-25.4mm, -26.55mm, -1.6mm), size=(50.8mm, 21.2mm, 0.1mm))
  C9_2.unite(ToolC9_2_1..ToolC9_2_7)
  C10_1 [CondMat10_1, surface CondMat10_1_surface] = rectangle(corner=(0mm, -21.45mm, -0.05mm), y_size=21.2mm, z_size=0.1mm)
  C10_1.sweep_around_axis(axis=Z, angle=90deg, segments=15)
  C10_1.move(25.4mm, -5.1mm, -1.75mm)
  ToolC10_1_1 = box(corner=(46.85mm, -5.1mm, -1.8mm), size=(-21.2mm, 10.2mm, 0.1mm))
  ToolC10_1_2 = rectangle(corner=(21.45mm, 0mm, -0.05mm), z_size=0.1mm, x_size=-21.2mm)
  ToolC10_1_2.sweep_around_axis(axis=Z, angle=90deg, segments=15)
  ToolC10_1_2.move(25.4mm, 5.1mm, -1.75mm)
  ToolC10_1_3 = box(corner=(25.4mm, 26.55mm, -1.8mm), size=(-50.8mm, -21.2mm, 0.1mm))
  ToolC10_1_4 = rectangle(corner=(0mm, 21.45mm, -0.05mm), y_size=-21.2mm, z_size=0.1mm)
  ToolC10_1_4.sweep_around_axis(axis=Z, angle=90deg, segments=15)
  ToolC10_1_4.move(-25.4mm, 5.1mm, -1.75mm)
  ToolC10_1_5 = box(corner=(-46.85mm, 5.1mm, -1.8mm), size=(21.2mm, -10.2mm, 0.1mm))
  ToolC10_1_6 = rectangle(corner=(-21.45mm, 0mm, -0.05mm), z_size=0.1mm, x_size=21.2mm)
  ToolC10_1_6.sweep_around_axis(axis=Z, angle=90deg, segments=15)
  ToolC10_1_6.move(-25.4mm, -5.1mm, -1.75mm)
  ToolC10_1_7 = box(corner=(-25.4mm, -26.55mm, -1.8mm), size=(50.8mm, 21.2mm, 0.1mm))
  C10_1.unite(ToolC10_1_1..ToolC10_1_7)
  C10_2 [CondMat10_2, surface CondMat10_2_surface] = rectangle(corner=(0mm, -21.45mm, -0.05mm), y_size=21.2mm, z_size=0.1mm)
  C10_2.sweep_around_axis(axis=Z, angle=90deg, segments=15)
  C10_2.move(25.4mm, -5.1mm, -1.95mm)
  ToolC10_2_1 = box(corner=(46.85mm, -5.1mm, -2mm), size=(-21.2mm, 10.2mm, 0.1mm))
  ToolC10_2_2 = rectangle(corner=(21.45mm, 0mm, -0.05mm), z_size=0.1mm, x_size=-21.2mm)
  ToolC10_2_2.sweep_around_axis(axis=Z, angle=90deg, segments=15)
  ToolC10_2_2.move(25.4mm, 5.1mm, -1.95mm)
  ToolC10_2_3 = box(corner=(25.4mm, 26.55mm, -2mm), size=(-50.8mm, -21.2mm, 0.1mm))
  ToolC10_2_4 = rectangle(corner=(0mm, 21.45mm, -0.05mm), y_size=-21.2mm, z_size=0.1mm)
  ToolC10_2_4.sweep_around_axis(axis=Z, angle=90deg, segments=15)
  ToolC10_2_4.move(-25.4mm, 5.1mm, -1.95mm)
  ToolC10_2_5 = box(corner=(-46.85mm, 5.1mm, -2mm), size=(21.2mm, -10.2mm, 0.1mm))
  ToolC10_2_6 = rectangle(corner=(-21.45mm, 0mm, -0.05mm), z_size=0.1mm, x_size=21.2mm)
  ToolC10_2_6.sweep_around_axis(axis=Z, angle=90deg, segments=15)
  ToolC10_2_6.move(-25.4mm, -5.1mm, -1.95mm)
  ToolC10_2_7 = box(corner=(-25.4mm, -26.55mm, -2mm), size=(50.8mm, 21.2mm, 0.1mm))
  C10_2.unite(ToolC10_2_1..ToolC10_2_7)
  C11_1 [CondMat11_1, surface CondMat11_1_surface] = rectangle(corner=(0mm, -21.45mm, -0.05mm), y_size=21.2mm, z_size=0.1mm)
  C11_1.sweep_around_axis(axis=Z, angle=90deg, segments=15)
  C11_1.move(25.4mm, -5.1mm, -2.15mm)
  ToolC11_1_1 = box(corner=(46.85mm, -5.1mm, -2.2mm), size=(-21.2mm, 10.2mm, 0.1mm))
  ToolC11_1_2 = rectangle(corner=(21.45mm, 0mm, -0.05mm), z_size=0.1mm, x_size=-21.2mm)
  ToolC11_1_2.sweep_around_axis(axis=Z, angle=90deg, segments=15)
  ToolC11_1_2.move(25.4mm, 5.1mm, -2.15mm)
  ToolC11_1_3 = box(corner=(25.4mm, 26.55mm, -2.2mm), size=(-50.8mm, -21.2mm, 0.1mm))
  ToolC11_1_4 = rectangle(corner=(0mm, 21.45mm, -0.05mm), y_size=-21.2mm, z_size=0.1mm)
  ToolC11_1_4.sweep_around_axis(axis=Z, angle=90deg, segments=15)
  ToolC11_1_4.move(-25.4mm, 5.1mm, -2.15mm)
  ToolC11_1_5 = box(corner=(-46.85mm, 5.1mm, -2.2mm), size=(21.2mm, -10.2mm, 0.1mm))
  ToolC11_1_6 = rectangle(corner=(-21.45mm, 0mm, -0.05mm), z_size=0.1mm, x_size=21.2mm)
  ToolC11_1_6.sweep_around_axis(axis=Z, angle=90deg, segments=15)
  ToolC11_1_6.move(-25.4mm, -5.1mm, -2.15mm)
  ToolC11_1_7 = box(corner=(-25.4mm, -26.55mm, -2.2mm), size=(50.8mm, 21.2mm, 0.1mm))
  C11_1.unite(ToolC11_1_1..ToolC11_1_7)
  C11_2 [CondMat11_2, surface CondMat11_2_surface] = rectangle(corner=(0mm, -21.45mm, -0.05mm), y_size=21.2mm, z_size=0.1mm)
  C11_2.sweep_around_axis(axis=Z, angle=90deg, segments=15)
  C11_2.move(25.4mm, -5.1mm, -2.35mm)
  ToolC11_2_1 = box(corner=(46.85mm, -5.1mm, -2.4mm), size=(-21.2mm, 10.2mm, 0.1mm))
  ToolC11_2_2 = rectangle(corner=(21.45mm, 0mm, -0.05mm), z_size=0.1mm, x_size=-21.2mm)
  ToolC11_2_2.sweep_around_axis(axis=Z, angle=90deg, segments=15)
  ToolC11_2_2.move(25.4mm, 5.1mm, -2.35mm)
  ToolC11_2_3 = box(corner=(25.4mm, 26.55mm, -2.4mm), size=(-50.8mm, -21.2mm, 0.1mm))
  ToolC11_2_4 = rectangle(corner=(0mm, 21.45mm, -0.05mm), y_size=-21.2mm, z_size=0.1mm)
  ToolC11_2_4.sweep_around_axis(axis=Z, angle=90deg, segments=15)
  ToolC11_2_4.move(-25.4mm, 5.1mm, -2.35mm)
  ToolC11_2_5 = box(corner=(-46.85mm, 5.1mm, -2.4mm), size=(21.2mm, -10.2mm, 0.1mm))
  ToolC11_2_6 = rectangle(corner=(-21.45mm, 0mm, -0.05mm), z_size=0.1mm, x_size=21.2mm)
  ToolC11_2_6.sweep_around_axis(axis=Z, angle=90deg, segments=15)
  ToolC11_2_6.move(-25.4mm, -5.1mm, -2.35mm)
  ToolC11_2_7 = box(corner=(-25.4mm, -26.55mm, -2.4mm), size=(50.8mm, 21.2mm, 0.1mm))
  C11_2.unite(ToolC11_2_1..ToolC11_2_7)
  C12_1 [CondMat12_1, surface CondMat12_1_surface] = rectangle(corner=(0mm, -21.45mm, -0.05mm), y_size=21.2mm, z_size=0.1mm)
  C12_1.sweep_around_axis(axis=Z, angle=90deg, segments=15)
  C12_1.move(25.4mm, -5.1mm, -2.55mm)
  ToolC12_1_1 = box(corner=(46.85mm, -5.1mm, -2.6mm), size=(-21.2mm, 10.2mm, 0.1mm))
  ToolC12_1_2 = rectangle(corner=(21.45mm, 0mm, -0.05mm), z_size=0.1mm, x_size=-21.2mm)
  ToolC12_1_2.sweep_around_axis(axis=Z, angle=90deg, segments=15)
  ToolC12_1_2.move(25.4mm, 5.1mm, -2.55mm)
  ToolC12_1_3 = box(corner=(25.4mm, 26.55mm, -2.6mm), size=(-50.8mm, -21.2mm, 0.1mm))
  ToolC12_1_4 = rectangle(corner=(0mm, 21.45mm, -0.05mm), y_size=-21.2mm, z_size=0.1mm)
  ToolC12_1_4.sweep_around_axis(axis=Z, angle=90deg, segments=15)
  ToolC12_1_4.move(-25.4mm, 5.1mm, -2.55mm)
  ToolC12_1_5 = box(corner=(-46.85mm, 5.1mm, -2.6mm), size=(21.2mm, -10.2mm, 0.1mm))
  ToolC12_1_6 = rectangle(corner=(-21.45mm, 0mm, -0.05mm), z_size=0.1mm, x_size=21.2mm)
  ToolC12_1_6.sweep_around_axis(axis=Z, angle=90deg, segments=15)
  ToolC12_1_6.move(-25.4mm, -5.1mm, -2.55mm)
  ToolC12_1_7 = box(corner=(-25.4mm, -26.55mm, -2.6mm), size=(50.8mm, 21.2mm, 0.1mm))
  C12_1.unite(ToolC12_1_1..ToolC12_1_7)
  C12_2 [CondMat12_2, surface CondMat12_2_surface] = rectangle(corner=(0mm, -21.45mm, -0.05mm), y_size=21.2mm, z_size=0.1mm)
  C12_2.sweep_around_axis(axis=Z, angle=90deg, segments=15)
  C12_2.move(25.4mm, -5.1mm, -2.75mm)
  ToolC12_2_1 = box(corner=(46.85mm, -5.1mm, -2.8mm), size=(-21.2mm, 10.2mm, 0.1mm))
  ToolC12_2_2 = rectangle(corner=(21.45mm, 0mm, -0.05mm), z_size=0.1mm, x_size=-21.2mm)
  ToolC12_2_2.sweep_around_axis(axis=Z, angle=90deg, segments=15)
  ToolC12_2_2.move(25.4mm, 5.1mm, -2.75mm)
  ToolC12_2_3 = box(corner=(25.4mm, 26.55mm, -2.8mm), size=(-50.8mm, -21.2mm, 0.1mm))
  ToolC12_2_4 = rectangle(corner=(0mm, 21.45mm, -0.05mm), y_size=-21.2mm, z_size=0.1mm)
  ToolC12_2_4.sweep_around_axis(axis=Z, angle=90deg, segments=15)
  ToolC12_2_4.move(-25.4mm, 5.1mm, -2.75mm)
  ToolC12_2_5 = box(corner=(-46.85mm, 5.1mm, -2.8mm), size=(21.2mm, -10.2mm, 0.1mm))
  ToolC12_2_6 = rectangle(corner=(-21.45mm, 0mm, -0.05mm), z_size=0.1mm, x_size=21.2mm)
  ToolC12_2_6.sweep_around_axis(axis=Z, angle=90deg, segments=15)
  ToolC12_2_6.move(-25.4mm, -5.1mm, -2.75mm)
  ToolC12_2_7 = box(corner=(-25.4mm, -26.55mm, -2.8mm), size=(50.8mm, 21.2mm, 0.1mm))
  C12_2.unite(ToolC12_2_1..ToolC12_2_7)
  C13_1 [CondMat13_1, surface CondMat13_1_surface] = rectangle(corner=(0mm, -21.45mm, -0.05mm), y_size=21.2mm, z_size=0.1mm)
  C13_1.sweep_around_axis(axis=Z, angle=90deg, segments=15)
  C13_1.move(25.4mm, -5.1mm, -2.95mm)
  ToolC13_1_1 = box(corner=(46.85mm, -5.1mm, -3mm), size=(-21.2mm, 10.2mm, 0.1mm))
  ToolC13_1_2 = rectangle(corner=(21.45mm, 0mm, -0.05mm), z_size=0.1mm, x_size=-21.2mm)
  ToolC13_1_2.sweep_around_axis(axis=Z, angle=90deg, segments=15)
  ToolC13_1_2.move(25.4mm, 5.1mm, -2.95mm)
  ToolC13_1_3 = box(corner=(25.4mm, 26.55mm, -3mm), size=(-50.8mm, -21.2mm, 0.1mm))
  ToolC13_1_4 = rectangle(corner=(0mm, 21.45mm, -0.05mm), y_size=-21.2mm, z_size=0.1mm)
  ToolC13_1_4.sweep_around_axis(axis=Z, angle=90deg, segments=15)
  ToolC13_1_4.move(-25.4mm, 5.1mm, -2.95mm)
  ToolC13_1_5 = box(corner=(-46.85mm, 5.1mm, -3mm), size=(21.2mm, -10.2mm, 0.1mm))
  ToolC13_1_6 = rectangle(corner=(-21.45mm, 0mm, -0.05mm), z_size=0.1mm, x_size=21.2mm)
  ToolC13_1_6.sweep_around_axis(axis=Z, angle=90deg, segments=15)
  ToolC13_1_6.move(-25.4mm, -5.1mm, -2.95mm)
  ToolC13_1_7 = box(corner=(-25.4mm, -26.55mm, -3mm), size=(50.8mm, 21.2mm, 0.1mm))
  C13_1.unite(ToolC13_1_1..ToolC13_1_7)
  C13_2 [CondMat13_2, surface CondMat13_2_surface] = rectangle(corner=(0mm, -21.45mm, -0.05mm), y_size=21.2mm, z_size=0.1mm)
  C13_2.sweep_around_axis(axis=Z, angle=90deg, segments=15)
  C13_2.move(25.4mm, -5.1mm, -3.15mm)
  ToolC13_2_1 = box(corner=(46.85mm, -5.1mm, -3.2mm), size=(-21.2mm, 10.2mm, 0.1mm))
  ToolC13_2_2 = rectangle(corner=(21.45mm, 0mm, -0.05mm), z_size=0.1mm, x_size=-21.2mm)
  ToolC13_2_2.sweep_around_axis(axis=Z, angle=90deg, segments=15)
  ToolC13_2_2.move(25.4mm, 5.1mm, -3.15mm)
  ToolC13_2_3 = box(corner=(25.4mm, 26.55mm, -3.2mm), size=(-50.8mm, -21.2mm, 0.1mm))
  ToolC13_2_4 = rectangle(corner=(0mm, 21.45mm, -0.05mm), y_size=-21.2mm, z_size=0.1mm)
  ToolC13_2_4.sweep_around_axis(axis=Z, angle=90deg, segments=15)
  ToolC13_2_4.move(-25.4mm, 5.1mm, -3.15mm)
  ToolC13_2_5 = box(corner=(-46.85mm, 5.1mm, -3.2mm), size=(21.2mm, -10.2mm, 0.1mm))
  ToolC13_2_6 = rectangle(corner=(-21.45mm, 0mm, -0.05mm), z_size=0.1mm, x_size=21.2mm)
  ToolC13_2_6.sweep_around_axis(axis=Z, angle=90deg, segments=15)
  ToolC13_2_6.move(-25.4mm, -5.1mm, -3.15mm)
  ToolC13_2_7 = box(corner=(-25.4mm, -26.55mm, -3.2mm), size=(50.8mm, 21.2mm, 0.1mm))
  C13_2.unite(ToolC13_2_1..ToolC13_2_7)
  C14_1 [CondMat14_1, surface CondMat14_1_surface] = rectangle(corner=(0mm, -21.45mm, -0.05mm), y_size=21.2mm, z_size=0.1mm)
  C14_1.sweep_around_axis(axis=Z, angle=90deg, segments=15)
  C14_1.move(25.4mm, -5.1mm, -3.35mm)
  ToolC14_1_1 = box(corner=(46.85mm, -5.1mm, -3.4mm), size=(-21.2mm, 10.2mm, 0.1mm))
  ToolC14_1_2 = rectangle(corner=(21.45mm, 0mm, -0.05mm), z_size=0.1mm, x_size=-21.2mm)
  ToolC14_1_2.sweep_around_axis(axis=Z, angle=90deg, segments=15)
  ToolC14_1_2.move(25.4mm, 5.1mm, -3.35mm)
  ToolC14_1_3 = box(corner=(25.4mm, 26.55mm, -3.4mm), size=(-50.8mm, -21.2mm, 0.1mm))
  ToolC14_1_4 = rectangle(corner=(0mm, 21.45mm, -0.05mm), y_size=-21.2mm, z_size=0.1mm)
  ToolC14_1_4.sweep_around_axis(axis=Z, angle=90deg, segments=15)
  ToolC14_1_4.move(-25.4mm, 5.1mm, -3.35mm)
  ToolC14_1_5 = box(corner=(-46.85mm, 5.1mm, -3.4mm), size=(21.2mm, -10.2mm, 0.1mm))
  ToolC14_1_6 = rectangle(corner=(-21.45mm, 0mm, -0.05mm), z_size=0.1mm, x_size=21.2mm)
  ToolC14_1_6.sweep_around_axis(axis=Z, angle=90deg, segments=15)
  ToolC14_1_6.move(-25.4mm, -5.1mm, -3.35mm)
  ToolC14_1_7 = box(corner=(-25.4mm, -26.55mm, -3.4mm), size=(50.8mm, 21.2mm, 0.1mm))
  C14_1.unite(ToolC14_1_1..ToolC14_1_7)
  C14_2 [CondMat14_2, surface CondMat14_2_surface] = rectangle(corner=(0mm, -21.45mm, -0.05mm), y_size=21.2mm, z_size=0.1mm)
  C14_2.sweep_around_axis(axis=Z, angle=90deg, segments=15)
  C14_2.move(25.4mm, -5.1mm, -3.55mm)
  ToolC14_2_1 = box(corner=(46.85mm, -5.1mm, -3.6mm), size=(-21.2mm, 10.2mm, 0.1mm))
  ToolC14_2_2 = rectangle(corner=(21.45mm, 0mm, -0.05mm), z_size=0.1mm, x_size=-21.2mm)
  ToolC14_2_2.sweep_around_axis(axis=Z, angle=90deg, segments=15)
  ToolC14_2_2.move(25.4mm, 5.1mm, -3.55mm)
  ToolC14_2_3 = box(corner=(25.4mm, 26.55mm, -3.6mm), size=(-50.8mm, -21.2mm, 0.1mm))
  ToolC14_2_4 = rectangle(corner=(0mm, 21.45mm, -0.05mm), y_size=-21.2mm, z_size=0.1mm)
  ToolC14_2_4.sweep_around_axis(axis=Z, angle=90deg, segments=15)
  ToolC14_2_4.move(-25.4mm, 5.1mm, -3.55mm)
  ToolC14_2_5 = box(corner=(-46.85mm, 5.1mm, -3.6mm), size=(21.2mm, -10.2mm, 0.1mm))
  ToolC14_2_6 = rectangle(corner=(-21.45mm, 0mm, -0.05mm), z_size=0.1mm, x_size=21.2mm)
  ToolC14_2_6.sweep_around_axis(axis=Z, angle=90deg, segments=15)
  ToolC14_2_6.move(-25.4mm, -5.1mm, -3.55mm)
  ToolC14_2_7 = box(corner=(-25.4mm, -26.55mm, -3.6mm), size=(50.8mm, 21.2mm, 0.1mm))
  C14_2.unite(ToolC14_2_1..ToolC14_2_7)
  C15_1 [CondMat15_1, surface CondMat15_1_surface] = rectangle(corner=(0mm, -21.45mm, -0.05mm), y_size=21.2mm, z_size=0.1mm)
  C15_1.sweep_around_axis(axis=Z, angle=90deg, segments=15)
  C15_1.move(25.4mm, -5.1mm, -3.75mm)
  ToolC15_1_1 = box(corner=(46.85mm, -5.1mm, -3.8mm), size=(-21.2mm, 10.2mm, 0.1mm))
  ToolC15_1_2 = rectangle(corner=(21.45mm, 0mm, -0.05mm), z_size=0.1mm, x_size=-21.2mm)
  ToolC15_1_2.sweep_around_axis(axis=Z, angle=90deg, segments=15)
  ToolC15_1_2.move(25.4mm, 5.1mm, -3.75mm)
  ToolC15_1_3 = box(corner=(25.4mm, 26.55mm, -3.8mm), size=(-50.8mm, -21.2mm, 0.1mm))
  ToolC15_1_4 = rectangle(corner=(0mm, 21.45mm, -0.05mm), y_size=-21.2mm, z_size=0.1mm)
  ToolC15_1_4.sweep_around_axis(axis=Z, angle=90deg, segments=15)
  ToolC15_1_4.move(-25.4mm, 5.1mm, -3.75mm)
  ToolC15_1_5 = box(corner=(-46.85mm, 5.1mm, -3.8mm), size=(21.2mm, -10.2mm, 0.1mm))
  ToolC15_1_6 = rectangle(corner=(-21.45mm, 0mm, -0.05mm), z_size=0.1mm, x_size=21.2mm)
  ToolC15_1_6.sweep_around_axis(axis=Z, angle=90deg, segments=15)
  ToolC15_1_6.move(-25.4mm, -5.1mm, -3.75mm)
  ToolC15_1_7 = box(corner=(-25.4mm, -26.55mm, -3.8mm), size=(50.8mm, 21.2mm, 0.1mm))
  C15_1.unite(ToolC15_1_1..ToolC15_1_7)
  C15_2 [CondMat15_2, surface CondMat15_2_surface] = rectangle(corner=(0mm, -21.45mm, -0.05mm), y_size=21.2mm, z_size=0.1mm)
  C15_2.sweep_around_axis(axis=Z, angle=90deg, segments=15)
  C15_2.move(25.4mm, -5.1mm, -3.95mm)
  ToolC15_2_1 = box(corner=(46.85mm, -5.1mm, -4mm), size=(-21.2mm, 10.2mm, 0.1mm))
  ToolC15_2_2 = rectangle(corner=(21.45mm, 0mm, -0.05mm), z_size=0.1mm, x_size=-21.2mm)
  ToolC15_2_2.sweep_around_axis(axis=Z, angle=90deg, segments=15)
  ToolC15_2_2.move(25.4mm, 5.1mm, -3.95mm)
  ToolC15_2_3 = box(corner=(25.4mm, 26.55mm, -4mm), size=(-50.8mm, -21.2mm, 0.1mm))
  ToolC15_2_4 = rectangle(corner=(0mm, 21.45mm, -0.05mm), y_size=-21.2mm, z_size=0.1mm)
  ToolC15_2_4.sweep_around_axis(axis=Z, angle=90deg, segments=15)
  ToolC15_2_4.move(-25.4mm, 5.1mm, -3.95mm)
  ToolC15_2_5 = box(corner=(-46.85mm, 5.1mm, -4mm), size=(21.2mm, -10.2mm, 0.1mm))
  ToolC15_2_6 = rectangle(corner=(-21.45mm, 0mm, -0.05mm), z_size=0.1mm, x_size=21.2mm)
  ToolC15_2_6.sweep_around_axis(axis=Z, angle=90deg, segments=15)
  ToolC15_2_6.move(-25.4mm, -5.1mm, -3.95mm)
  ToolC15_2_7 = box(corner=(-25.4mm, -26.55mm, -4mm), size=(50.8mm, 21.2mm, 0.1mm))
  C15_2.unite(ToolC15_2_1..ToolC15_2_7)
  C16_1 [CondMat16_1, surface CondMat16_1_surface] = rectangle(corner=(0mm, -21.45mm, -0.05mm), y_size=21.2mm, z_size=0.1mm)
  C16_1.sweep_around_axis(axis=Z, angle=90deg, segments=15)
  C16_1.move(25.4mm, -5.1mm, -4.15mm)
  ToolC16_1_1 = box(corner=(46.85mm, -5.1mm, -4.2mm), size=(-21.2mm, 10.2mm, 0.1mm))
  ToolC16_1_2 = rectangle(corner=(21.45mm, 0mm, -0.05mm), z_size=0.1mm, x_size=-21.2mm)
  ToolC16_1_2.sweep_around_axis(axis=Z, angle=90deg, segments=15)
  ToolC16_1_2.move(25.4mm, 5.1mm, -4.15mm)
  ToolC16_1_3 = box(corner=(25.4mm, 26.55mm, -4.2mm), size=(-50.8mm, -21.2mm, 0.1mm))
  ToolC16_1_4 = rectangle(corner=(0mm, 21.45mm, -0.05mm), y_size=-21.2mm, z_size=0.1mm)
  ToolC16_1_4.sweep_around_axis(axis=Z, angle=90deg, segments=15)
  ToolC16_1_4.move(-25.4mm, 5.1mm, -4.15mm)
  ToolC16_1_5 = box(corner=(-46.85mm, 5.1mm, -4.2mm), size=(21.2mm, -10.2mm, 0.1mm))
  ToolC16_1_6 = rectangle(corner=(-21.45mm, 0mm, -0.05mm), z_size=0.1mm, x_size=21.2mm)
  ToolC16_1_6.sweep_around_axis(axis=Z, angle=90deg, segments=15)
  ToolC16_1_6.move(-25.4mm, -5.1mm, -4.15mm)
  ToolC16_1_7 = box(corner=(-25.4mm, -26.55mm, -4.2mm), size=(50.8mm, 21.2mm, 0.1mm))
  C16_1.unite(ToolC16_1_1..ToolC16_1_7)
  Core.move(0mm, 0mm, 0.03mm)
  Core.move(0mm, 0mm, 0.2mm)
boundaries and excitations:
  P1_3: Block Objects=C1_3 Block_Type=Solid Total_Power=P1/72
  P1_2: Block Objects=C1_2 Block_Type=Solid Total_Power=P1/72
  P1_1: Block Objects=C1_1 Block_Type=Solid Total_Power=P1/72
  P1_6: Block Objects=C1_6 Block_Type=Solid Total_Power=P1/72
  P1_5: Block Objects=C1_5 Block_Type=Solid Total_Power=P1/72
  P1_4: Block Objects=C1_4 Block_Type=Solid Total_Power=P1/72
  P1_9: Block Objects=C1_9 Block_Type=Solid Total_Power=P1/72
  P1_8: Block Objects=C1_8 Block_Type=Solid Total_Power=P1/72
  P1_7: Block Objects=C1_7 Block_Type=Solid Total_Power=P1/72
  P1_12: Block Objects=C1_12 Block_Type=Solid Total_Power=P1/72
  P1_11: Block Objects=C1_11 Block_Type=Solid Total_Power=P1/72
  P1_10: Block Objects=C1_10 Block_Type=Solid Total_Power=P1/72
  P1_15: Block Objects=C1_15 Block_Type=Solid Total_Power=P1/72
  P1_14: Block Objects=C1_14 Block_Type=Solid Total_Power=P1/72
  P1_13: Block Objects=C1_13 Block_Type=Solid Total_Power=P1/72
  P1_18: Block Objects=C1_18 Block_Type=Solid Total_Power=P1/72
  P1_17: Block Objects=C1_17 Block_Type=Solid Total_Power=P1/72
  P1_16: Block Objects=C1_16 Block_Type=Solid Total_Power=P1/72
  P2_3: Block Objects=C2_3 Block_Type=Solid Total_Power=P1/72
  P2_2: Block Objects=C2_2 Block_Type=Solid Total_Power=P1/72
  P2_1: Block Objects=C2_1 Block_Type=Solid Total_Power=P1/72
  P2_6: Block Objects=C2_6 Block_Type=Solid Total_Power=P1/72
  P2_5: Block Objects=C2_5 Block_Type=Solid Total_Power=P1/72
  P2_4: Block Objects=C2_4 Block_Type=Solid Total_Power=P1/72
  P2_9: Block Objects=C2_9 Block_Type=Solid Total_Power=P1/72
  P2_8: Block Objects=C2_8 Block_Type=Solid Total_Power=P1/72
  P2_7: Block Objects=C2_7 Block_Type=Solid Total_Power=P1/72
  P2_12: Block Objects=C2_12 Block_Type=Solid Total_Power=P1/72
  P2_11: Block Objects=C2_11 Block_Type=Solid Total_Power=P1/72
  P2_10: Block Objects=C2_10 Block_Type=Solid Total_Power=P1/72
  P2_15: Block Objects=C2_15 Block_Type=Solid Total_Power=P1/72
  P2_14: Block Objects=C2_14 Block_Type=Solid Total_Power=P1/72
  P2_13: Block Objects=C2_13 Block_Type=Solid Total_Power=P1/72
  P2_18: Block Objects=C2_18 Block_Type=Solid Total_Power=P1/72
  P2_17: Block Objects=C2_17 Block_Type=Solid Total_Power=P1/72
  P2_16: Block Objects=C2_16 Block_Type=Solid Total_Power=P1/72
  P3_3: Block Objects=C3_3 Block_Type=Solid Total_Power=P1/72
  P3_2: Block Objects=C3_2 Block_Type=Solid Total_Power=P1/72
  P3_1: Block Objects=C3_1 Block_Type=Solid Total_Power=P1/72
  P3_6: Block Objects=C3_6 Block_Type=Solid Total_Power=P1/72
  P3_5: Block Objects=C3_5 Block_Type=Solid Total_Power=P1/72
  P3_4: Block Objects=C3_4 Block_Type=Solid Total_Power=P1/72
  P3_9: Block Objects=C3_9 Block_Type=Solid Total_Power=P1/72
  P3_8: Block Objects=C3_8 Block_Type=Solid Total_Power=P1/72
  P3_7: Block Objects=C3_7 Block_Type=Solid Total_Power=P1/72
  P3_12: Block Objects=C3_12 Block_Type=Solid Total_Power=P1/72
  P3_11: Block Objects=C3_11 Block_Type=Solid Total_Power=P1/72
  P3_10: Block Objects=C3_10 Block_Type=Solid Total_Power=P1/72
  P3_15: Block Objects=C3_15 Block_Type=Solid Total_Power=P1/72
  P3_14: Block Objects=C3_14 Block_Type=Solid Total_Power=P1/72
  P3_13: Block Objects=C3_13 Block_Type=Solid Total_Power=P1/72
  P3_18: Block Objects=C3_18 Block_Type=Solid Total_Power=P1/72
  P3_17: Block Objects=C3_17 Block_Type=Solid Total_Power=P1/72
  P3_16: Block Objects=C3_16 Block_Type=Solid Total_Power=P1/72
  P4_3: Block Objects=C4_3 Block_Type=Solid Total_Power=P1/72
  P4_2: Block Objects=C4_2 Block_Type=Solid Total_Power=P1/72
  P4_1: Block Objects=C4_1 Block_Type=Solid Total_Power=P1/72
  P4_6: Block Objects=C4_6 Block_Type=Solid Total_Power=P1/72
  P4_5: Block Objects=C4_5 Block_Type=Solid Total_Power=P1/72
  P4_4: Block Objects=C4_4 Block_Type=Solid Total_Power=P1/72
  P4_9: Block Objects=C4_9 Block_Type=Solid Total_Power=P1/72
  P4_8: Block Objects=C4_8 Block_Type=Solid Total_Power=P1/72
  P4_7: Block Objects=C4_7 Block_Type=Solid Total_Power=P1/72
  P4_12: Block Objects=C4_12 Block_Type=Solid Total_Power=P1/72
  P4_11: Block Objects=C4_11 Block_Type=Solid Total_Power=P1/72
  P4_10: Block Objects=C4_10 Block_Type=Solid Total_Power=P1/72
  P4_15: Block Objects=C4_15 Block_Type=Solid Total_Power=P1/72
  P4_14: Block Objects=C4_14 Block_Type=Solid Total_Power=P1/72
  P4_13: Block Objects=C4_13 Block_Type=Solid Total_Power=P1/72
  P4_18: Block Objects=C4_18 Block_Type=Solid Total_Power=P1/72
  P4_17: Block Objects=C4_17 Block_Type=Solid Total_Power=P1/72
  P4_16: Block Objects=C4_16 Block_Type=Solid Total_Power=P1/72
  P5_1: Block Objects=C5_1 Block_Type=Solid Total_Power=P2/24
  P5_2: Block Objects=C5_2 Block_Type=Solid Total_Power=P2/24
  P6_1: Block Objects=C6_1 Block_Type=Solid Total_Power=P2/24
  P6_2: Block Objects=C6_2 Block_Type=Solid Total_Power=P2/24
  P7_1: Block Objects=C7_1 Block_Type=Solid Total_Power=P2/24
  P7_2: Block Objects=C7_2 Block_Type=Solid Total_Power=P2/24
  P8_1: Block Objects=C8_1 Block_Type=Solid Total_Power=P2/24
  P8_2: Block Objects=C8_2 Block_Type=Solid Total_Power=P2/24
  P9_1: Block Objects=C9_1 Block_Type=Solid Total_Power=P2/24
  P9_2: Block Objects=C9_2 Block_Type=Solid Total_Power=P2/24
  P10_1: Block Objects=C10_1 Block_Type=Solid Total_Power=P2/24
  P10_2: Block Objects=C10_2 Block_Type=Solid Total_Power=P2/24
  P11_1: Block Objects=C11_1 Block_Type=Solid Total_Power=P2/24
  P11_2: Block Objects=C11_2 Block_Type=Solid Total_Power=P2/24
  P12_1: Block Objects=C12_1 Block_Type=Solid Total_Power=P2/24
  P12_2: Block Objects=C12_2 Block_Type=Solid Total_Power=P2/24
  P13_1: Block Objects=C13_1 Block_Type=Solid Total_Power=P2/24
  P13_2: Block Objects=C13_2 Block_Type=Solid Total_Power=P2/24
  P14_1: Block Objects=C14_1 Block_Type=Solid Total_Power=P2/24
  P14_2: Block Objects=C14_2 Block_Type=Solid Total_Power=P2/24
  P15_1: Block Objects=C15_1 Block_Type=Solid Total_Power=P2/24
  P15_2: Block Objects=C15_2 Block_Type=Solid Total_Power=P2/24
  P16_1: Block Objects=C16_1 Block_Type=Solid Total_Power=P2/24
mesh:
  MeshRegions:  Global{MeshMethod=MesherHD UserSpecifiedSettings ComputeGap MaxElementSizeX=1mm MaxElementSizeY=1mm MaxElementSizeZ=1mm MinElementsInGap=3 MinElementsOnEdge=2 MaxSizeRatio=2 EnableMLM EnforeMLMType=None MaxLevels=3 BufferLayers=0 UniformMeshParametersType=Average MinGapX=0.0125mm MinGapY=0.0125mm MinGapZ=0.0125mm Objects=Region FacetLevel=3 ProximitySizeFunction CurvatureSizeFunction}
  MeshOperations:
